simulator lang=spectre
global 0
parameters lg_vbiasp={{lg_vbiasp}} nA={{nA}} nB10={{nB10}} nB11={{nB11}} nB12={{nB12}} nB13={{nB13}} nB14={{nB14}} nB15={{nB15}} nB16={{nB16}} nB17={{nB17}} nB18={{nB18}} nB19={{nB19}} nB1={{nB1}} nB2={{nB2}} nB3={{nB3}} nB4={{nB4}} nB5={{nB5}} nB6={{nB6}} nB7={{nB7}} nB8={{nB8}} nB9={{nB9}} tempc={{tempc}} vbiasp={{vbiasp}} vcm={{vcm}} vdd={{vdd}}
include "/homes/natelgrw/Documents/TURBO_circuit_optimizer/lstp/7nfet.pm"
include "/homes/natelgrw/Documents/TURBO_circuit_optimizer/lstp/7pfet.pm"

subckt single_ended_current_mirror Vbiasn Vinn Vinp Voutn
*.PININFO Vbiasn:I Vinn:I Vinp:I Voutn:O
MM8 net9 net9 gnd! gnd! nfet l=nA nfin=nB1
MM7 Voutn net9 gnd! gnd! nfet l=nA nfin=nB1
MM3 net20 Vinp net16 gnd! nfet l=nA nfin=nB2
MM0 net11 Vinn net16 gnd! nfet l=nA nfin=nB2
MM4 net16 Vbiasn gnd! gnd! nfet l=nA nfin=nB3
MM6 net9 net11 vdd! vdd! pfet l=nA nfin=nB4
MM5 Voutn net20 vdd! vdd! pfet l=nA nfin=nB5
MM1 net20 net20 vdd! vdd! pfet l=nA nfin=nB5
MM2 net11 net11 vdd! vdd! pfet l=nA nfin=nB4
ends single_ended_current_mirror

subckt LG_npmos Biasn Vbiasn Vbiasp
*.PININFO Biasn:I Vbiasn:O Vbiasp:O
MM4 Vbiasp Vbiasn gnd! gnd! nfet l=nA nfin=nB6
MM2 Vbiasn Vbiasn gnd! gnd! nfet l=nA nfin=nB7
MM10 neta Biasn gnd! gnd! nfet l=nA nfin=nB8
MM3 Vbiasp Vbiasp vdd! vdd! pfet l=nA nfin=nB9
MM1 Vbiasn neta vdd! vdd! pfet l=nA nfin=nB10
MM0 neta neta vdd! vdd! pfet l=nA nfin=nB10
ends LG_npmos

subckt CR4_2 Vbiasn Vbiasp
*.PININFO Vbiasn:O Vbiasp:O
MM11 net023 net024 Vbiasn gnd! nfet l=nA nfin=nB11
MM8 net025 net010 net023 gnd! nfet l=nA nfin=nB12
MM9 net024 net024 net023 gnd! nfet l=nA nfin=nB13
MM7 net010 net010 net025 gnd! nfet l=nA nfin=nB14
MM2 Vbiasn Vbiasn gnd! gnd! nfet l=nA nfin=nB15
MM0 Vbiasp net025 gnd! gnd! nfet l=nA nfin=nB16
MM10 net024 Vbiasp vdd! vdd! pfet l=nA nfin=nB17
MM4 net010 Vbiasp vdd! vdd! pfet l=nA nfin=nB18
MM3 Vbiasn Vbiasp vdd! vdd! pfet l=nA nfin=nB17
MM1 Vbiasp Vbiasp vdd! vdd! pfet l=nA nfin=nB19
ends CR4_2

VS (gnd! 0) vsource dc=0 type=dc
V0 (vdd! gnd!) vsource dc=vdd type=dc
V2 (in gnd!) vsource type=dc mag=1
E1 (Vinp cm in gnd!) vcvs gain=.5
E0 (Vinn cm in gnd!) vcvs gain=-0.5
V1 (cm gnd!) vsource dc=vcm type=dc
VP0 (LG_Vbiasp gnd!) vsource dc=lg_vbiasp type=dc
VP1 (Vbiasp gnd!) vsource dc=vbiasp type=dc

xiota LG_Vbiasn Vinn Vinp Voutn single_ended_current_mirror

xiLG_npmos Biasn LG_Vbiasn LG_Vbiasp LG_npmos

xibCR4_2 Biasn Vbiasp CR4_2

simulatorOptions options psfversion="1.4.0" reltol=1e-3 vabstol=1e-6 \
    iabstol=1e-12 temp=tempc tnom=27 scalem=1.0 scale=1.0 gmin=1e-12 rforce=1 \
    maxnotes=5 maxwarns=5 digits=5 cols=80 pivrel=1e-3 \
    sensfile="../psf/sens.output" checklimitdest=psf
    ac ac start=1 stop=100G dec=10 annotate=status
dcOp dc write="spectre.dc" maxiters=150 maxsteps=10000 annotate=status
dcOpInfo info what=oppoint where=rawfile
modelParameter info what=models where=rawfile
element info what=inst where=rawfile
outputParameter info what=output where=rawfile
designParamVals info what=parameters where=rawfile
primitives info what=primitives where=rawfile
subckts info what=subckts where=rawfile
saveOptions options save=allpub
