simulator lang=spectre
global 0
parameters lg_vbiasn={{lg_vbiasn}} lg_vbiasp1={{lg_vbiasp1}} nA={{nA}} nB10={{nB10}} nB11={{nB11}} nB12={{nB12}} nB13={{nB13}} nB14={{nB14}} nB15={{nB15}} nB16={{nB16}} nB17={{nB17}} nB1={{nB1}} nB2={{nB2}} nB3={{nB3}} nB4={{nB4}} nB5={{nB5}} nB6={{nB6}} nB7={{nB7}} nB8={{nB8}} nB9={{nB9}} tempc={{tempc}} vbiasp={{vbiasp}} vcm={{vcm}} vdd={{vdd}}
include "/homes/natelgrw/Documents/TURBO_circuit_optimizer/lstp/7nfet.pm"
include "/homes/natelgrw/Documents/TURBO_circuit_optimizer/lstp/7pfet.pm"

subckt fully_differential_current_mirror_pmos Vbiasp Vbiasp1 Vinn Vinp Voutn Voutp
*.PININFO Vbiasp:I Vbiasp1:I Vinn:I Vinp:I Voutn:O Voutp:O
MM1 Voutp net13 gnd! gnd! nfet l=nA nfin=nB1
MM9 net13 net13 gnd! gnd! nfet l=nA nfin=nB1
MM0 Voutn net19 gnd! gnd! nfet l=nA nfin=nB2
MM8 net19 net19 gnd! gnd! nfet l=nA nfin=nB2
MM3 Voutp Vbiasp1 vdd! vdd! pfet l=nA nfin=nB3
MM2 Voutn Vbiasp1 vdd! vdd! pfet l=nA nfin=nB3
MM5 net17 Vbiasp vdd! vdd! pfet l=nA nfin=nB4
MM7 net13 Vinn net17 net24 pfet l=nA nfin=nB5
MM6 net19 Vinp net17 net24 pfet l=nA nfin=nB5
ends fully_differential_current_mirror_pmos

subckt LG_nmos_l1 Biasn Vbiasn Vbiasp
*.PININFO Biasn:I Vbiasn:O Vbiasp:O
MM2 Vbiasn Vbiasn gnd! gnd! nfet l=nA nfin=nB6
MM10 Vbiasp Biasn gnd! gnd! nfet l=nA nfin=nB7
MM1 Vbiasn Vbiasp vdd! vdd! pfet l=nA nfin=nB8
MM0 Vbiasp Vbiasp vdd! vdd! pfet l=nA nfin=nB8
ends LG_nmos_l1

subckt CR4_2 Vbiasn Vbiasp
*.PININFO Vbiasn:O Vbiasp:O
MM11 net023 net024 Vbiasn gnd! nfet l=nA nfin=nB9
MM8 net025 net010 net023 gnd! nfet l=nA nfin=nB10
MM9 net024 net024 net023 gnd! nfet l=nA nfin=nB11
MM7 net010 net010 net025 gnd! nfet l=nA nfin=nB12
MM2 Vbiasn Vbiasn gnd! gnd! nfet l=nA nfin=nB13
MM0 Vbiasp net025 gnd! gnd! nfet l=nA nfin=nB14
MM10 net024 Vbiasp vdd! vdd! pfet l=nA nfin=nB15
MM4 net010 Vbiasp vdd! vdd! pfet l=nA nfin=nB16
MM3 Vbiasn Vbiasp vdd! vdd! pfet l=nA nfin=nB15
MM1 Vbiasp Vbiasp vdd! vdd! pfet l=nA nfin=nB17
ends CR4_2

VS (gnd! 0) vsource dc=0 type=dc
V0 (vdd! gnd!) vsource dc=vdd type=dc
V2 (in gnd!) vsource type=dc mag=1
E1 (Vinp cm in gnd!) vcvs gain=.5
E0 (Vinn cm in gnd!) vcvs gain=-0.5
V1 (cm gnd!) vsource dc=vcm type=dc
VP0 (LG_Vbiasp1 gnd!) vsource dc=lg_vbiasp1 type=dc
VN0 (LG_Vbiasn gnd!) vsource dc=lg_vbiasn type=dc
VP1 (Vbiasp gnd!) vsource dc=vbiasp type=dc

xiota LG_Vbiasp LG_Vbiasp1 Vinn Vinp Voutn Voutp fully_differential_current_mirror_pmos

xiLG_nmos_l1 Biasn LG_Vbiasn LG_Vbiasp LG_nmos_l1

xibCR4_2 Biasn Vbiasp CR4_2

simulatorOptions options psfversion="1.4.0" reltol=1e-3 vabstol=1e-6 \
    iabstol=1e-12 temp=tempc tnom=27 scalem=1.0 scale=1.0 gmin=1e-12 rforce=1 \
    maxnotes=5 maxwarns=5 digits=5 cols=80 pivrel=1e-3 \
    sensfile="../psf/sens.output" checklimitdest=psf
    ac ac start=1 stop=100G dec=10 annotate=status
dcOp dc write="spectre.dc" maxiters=150 maxsteps=10000 annotate=status
dcOpInfo info what=oppoint where=rawfile
modelParameter info what=models where=rawfile
element info what=inst where=rawfile
outputParameter info what=output where=rawfile
designParamVals info what=parameters where=rawfile
primitives info what=primitives where=rawfile
subckts info what=subckts where=rawfile
saveOptions options save=allpub
