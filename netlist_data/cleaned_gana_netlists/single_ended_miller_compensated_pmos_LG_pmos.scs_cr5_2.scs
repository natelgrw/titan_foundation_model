simulator lang=spectre
global 0
parameters nA={{nA}} nB10={{nB10}} nB1={{nB1}} nB2={{nB2}} nB3={{nB3}} nB4={{nB4}} nB5={{nB5}} nB6={{nB6}} nB7={{nB7}} nB8={{nB8}} nB9={{nB9}} nC0={{nC0}} tempc={{tempc}} vbiasp={{vbiasp}} vcm={{vcm}} vdd={{vdd}}
include "/homes/natelgrw/Documents/TURBO_circuit_optimizer/lstp/7nfet.pm"
include "/homes/natelgrw/Documents/TURBO_circuit_optimizer/lstp/7pfet.pm"

subckt single_ended_miller_compensated_pmos Vbiasp Vinn Vinp Voutp
*.PININFO Vbiasp:I Vinn:I Vinp:I Voutp:O
MM13 Voutp net38 gnd! gnd! nfet l=nA nfin=nB1
MM9 net38 net35 gnd! gnd! nfet l=nA nfin=nB2
MM8 net35 net35 gnd! gnd! nfet l=nA nfin=nB2
MM12 Voutp Vbiasp vdd! vdd! pfet l=nA nfin=nB3
MM11 net33 Vbiasp vdd! vdd! pfet l=nA nfin=nB3
MM10 net38 Vinn net33 net39 pfet l=nA nfin=nB4
MM7 net35 Vinp net33 net39 pfet l=nA nfin=nB4
C2 Voutp net38 capacitor c=nC2
ends single_ended_miller_compensated_pmos

subckt LG_pmos Biasn Vbiasp
*.PININFO Biasn:I Vbiasp:O
MM10 Vbiasp Biasn gnd! gnd! nfet l=nA nfin=nB5
MM3 Vbiasp Vbiasp vdd! vdd! pfet l=nA nfin=nB6
ends LG_pmos

subckt CR5_2 Vbiasn Vbiasp
*.PININFO Vbiasn:O Vbiasp:O
MM5 net014 net014 gnd! gnd! nfet l=nA nfin=nB7
MM4 net15 net014 gnd! gnd! nfet l=nA nfin=nB7
MM2 Vbiasp Vbiasn net15 gnd! nfet l=nA nfin=nB8
MM0 Vbiasn Vbiasn gnd! gnd! nfet l=nA nfin=nB8
MM6 net014 Vbiasp vdd! vdd! pfet l=nA nfin=nB9
MM3 Vbiasp Vbiasp vdd! vdd! pfet l=nA nfin=nB10
MM1 Vbiasn Vbiasp vdd! vdd! pfet l=nA nfin=nB10
ends CR5_2

VS (gnd! 0) vsource dc=0 type=dc
V0 (vdd! gnd!) vsource dc=vdd type=dc
V2 (in gnd!) vsource type=dc mag=1
E1 (Vinp cm in gnd!) vcvs gain=.5
E0 (Vinn cm in gnd!) vcvs gain=-0.5
V1 (cm gnd!) vsource dc=vcm type=dc
VP0 (Vbiasp gnd!) vsource dc=vbiasp type=dc

xiota LG_Vbiasp Vinn Vinp Voutp single_ended_miller_compensated_pmos

xiLG_pmos Biasn LG_Vbiasp LG_pmos

xibCR5_2 Biasn Vbiasp CR5_2

simulatorOptions options psfversion="1.4.0" reltol=1e-3 vabstol=1e-6 \
    iabstol=1e-12 temp=tempc tnom=27 scalem=1.0 scale=1.0 gmin=1e-12 rforce=1 \
    maxnotes=5 maxwarns=5 digits=5 cols=80 pivrel=1e-3 \
    sensfile="../psf/sens.output" checklimitdest=psf
    ac ac start=1 stop=100G dec=10 annotate=status
dcOp dc write="spectre.dc" maxiters=150 maxsteps=10000 annotate=status
dcOpInfo info what=oppoint where=rawfile
modelParameter info what=models where=rawfile
element info what=inst where=rawfile
outputParameter info what=output where=rawfile
designParamVals info what=parameters where=rawfile
primitives info what=primitives where=rawfile
subckts info what=subckts where=rawfile
saveOptions options save=allpub
