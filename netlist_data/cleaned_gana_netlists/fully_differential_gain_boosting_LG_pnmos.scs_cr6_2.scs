simulator lang=spectre
global 0
parameters biasn1={{biasn1}} biasn2={{biasn2}} nA={{nA}} nB10={{nB10}} nB11={{nB11}} nB12={{nB12}} nB13={{nB13}} nB14={{nB14}} nB15={{nB15}} nB16={{nB16}} nB17={{nB17}} nB1={{nB1}} nB2={{nB2}} nB3={{nB3}} nB4={{nB4}} nB5={{nB5}} nB6={{nB6}} nB7={{nB7}} nB8={{nB8}} nB9={{nB9}} tempc={{tempc}} vcm={{vcm}} vdd={{vdd}}
include "/homes/natelgrw/Documents/TURBO_circuit_optimizer/lstp/7nfet.pm"
include "/homes/natelgrw/Documents/TURBO_circuit_optimizer/lstp/7pfet.pm"

subckt fully_differential Vinn Vinp Voutn Voutp
*.PININFO Vinn:I Vinp:I Voutn:O Voutp:O
MM1 Voutn Vbiasp vdd! vdd! pfet l=nA nfin=nB1
MM2 Voutp Vbiasp vdd! vdd! pfet l=nA nfin=nB1
MM4 net14 Vbiasn gnd! gnd! nfet l=nA nfin=nB2
MM3 Voutn Vinp net14 gnd! nfet l=nA nfin=nB3
MM0 Voutp Vinn net14 gnd! nfet l=nA nfin=nB3
ends fully_differential

subckt fully_differential_gain_boosting Vbiasn Vbiasp Vinn Vinp Voutn Voutp
*.PININFO Vbiasn:I Vbiasp:O Vinn:I Vinp:I Voutn:O Voutp:O
MM8 Voutn net22 net23 gnd! nfet l=nA nfin=nB4
MM7 Voutp net19 net21 gnd! nfet l=nA nfin=nB4
MM3 net23 Vinp net15 gnd! nfet l=nA nfin=nB5
MM0 net21 Vinn net15 gnd! nfet l=nA nfin=nB5
MM4 net15 Vbiasn gnd! gnd! nfet l=nA nfin=nB6
MM6 Voutn net24 net25 vdd pfet l=nA nfin=nB7
MM5 Voutp net20 net12 vdd pfet l=nA nfin=nB7
MM1 net25 Vbiasp vdd! vdd! pfet l=nA nfin=nB8
MM2 net12 Vbiasp vdd! vdd! pfet l=nA nfin=nB8
XI3 net12 net25 net24 net20 fully_differential
XI1 net23 net21 net19 net22 fully_differential
ends fully_differential_gain_boosting

subckt LG_pnmos Biasp Vbiasn Vbiasp
*.PININFO Biasp:I Vbiasn:O Vbiasp:O
MM1 Vbiasn Vbiasn gnd! gnd! nfet l=nA nfin=nB9
MM0 Vbiasp net6 gnd! gnd! nfet l=nA nfin=nB10
MM8 net6 net6 gnd! gnd! nfet l=nA nfin=nB10
MM2 Vbiasn Vbiasp vdd! vdd! pfet l=nA nfin=nB11
MM3 Vbiasp Vbiasp vdd! vdd! pfet l=nA nfin=nB11
MM10 net6 Biasp vdd! vdd! pfet l=nA nfin=nB12
ends LG_pnmos

subckt CR6_2 Vbiasn1 Vbiasn2 Vbiasp
*.PININFO Vbiasn1:O Vbiasn2:O Vbiasp:O
MM2 Vbiasp Vbiasn2 Vbiasn1 gnd! nfet l=nA nfin=nB13
MM0 Vbiasn2 Vbiasn1 gnd! gnd! nfet l=nA nfin=nB14
MM4 Vbiasn1 net15 gnd! gnd! nfet l=nA nfin=nB15
MM5 net15 net15 gnd! gnd! nfet l=nA nfin=nB15
MM3 Vbiasp Vbiasp vdd! vdd! pfet l=nA nfin=nB16
MM1 Vbiasn2 Vbiasp vdd! vdd! pfet l=nA nfin=nB16
MM6 net15 Vbiasp vdd! vdd! pfet l=nA nfin=nB17
ends CR6_2

VS (gnd! 0) vsource dc=0 type=dc
V0 (vdd! gnd!) vsource dc=vdd type=dc
V2 (in gnd!) vsource type=dc mag=1
E1 (Vinp cm in gnd!) vcvs gain=.5
E0 (Vinn cm in gnd!) vcvs gain=-0.5
V1 (cm gnd!) vsource dc=vcm type=dc
VN0 (Biasn1 gnd!) vsource dc=biasn1 type=dc
VN1 (Biasn2 gnd!) vsource dc=biasn2 type=dc

xiota LG_Vbiasn LG_Vbiasp Vinn Vinp Voutn Voutp fully_differential_gain_boosting

xiLG_pnmos Biasp LG_Vbiasn LG_Vbiasp LG_pnmos

xibCR6_2 Biasn1 Biasn2 Biasp CR6_2

simulatorOptions options psfversion="1.4.0" reltol=1e-3 vabstol=1e-6 \
    iabstol=1e-12 temp=tempc tnom=27 scalem=1.0 scale=1.0 gmin=1e-12 rforce=1 \
    maxnotes=5 maxwarns=5 digits=5 cols=80 pivrel=1e-3 \
    sensfile="../psf/sens.output" checklimitdest=psf
    ac ac start=1 stop=100G dec=10 annotate=status
dcOp dc write="spectre.dc" maxiters=150 maxsteps=10000 annotate=status
dcOpInfo info what=oppoint where=rawfile
modelParameter info what=models where=rawfile
element info what=inst where=rawfile
outputParameter info what=output where=rawfile
designParamVals info what=parameters where=rawfile
primitives info what=primitives where=rawfile
subckts info what=subckts where=rawfile
saveOptions options save=allpub
