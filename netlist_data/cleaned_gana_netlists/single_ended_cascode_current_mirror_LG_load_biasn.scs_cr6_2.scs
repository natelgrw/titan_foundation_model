simulator lang=spectre
global 0
parameters biasn1={{biasn1}} biasn2={{biasn2}} lg_vbiasn1={{lg_vbiasn1}} lg_vbiasn={{lg_vbiasn}} lg_vbiasp2={{lg_vbiasp2}} nA={{nA}} nB10={{nB10}} nB11={{nB11}} nB12={{nB12}} nB13={{nB13}} nB14={{nB14}} nB15={{nB15}} nB16={{nB16}} nB1={{nB1}} nB2={{nB2}} nB3={{nB3}} nB4={{nB4}} nB5={{nB5}} nB6={{nB6}} nB7={{nB7}} nB8={{nB8}} nB9={{nB9}} tempc={{tempc}} vcm={{vcm}} vdd={{vdd}}
include "/homes/natelgrw/Documents/TURBO_circuit_optimizer/lstp/7nfet.pm"
include "/homes/natelgrw/Documents/TURBO_circuit_optimizer/lstp/7pfet.pm"

subckt single_ended_cascode_current_mirror Vbiasn Vbiasn2 Vbiasp2 Vinn Vinp Voutn
*.PININFO Vbiasn:I Vbiasn2:I Vbiasp2:I Vinn:I Vinp:I Voutn:O
MM12 net12 Vbiasp2 net37 vdd! pfet l=nA nfin=nB1
MM11 net23 Vbiasp2 net36 vdd! pfet l=nA nfin=nB2
MM10 net10 Vbiasp2 net35 vdd! pfet l=nA nfin=nB1
MM9 Voutn Vbiasp2 net34 vdd! pfet l=nA nfin=nB2
MM2 net37 net12 vdd! vdd! pfet l=nA nfin=nB3
MM1 net36 net23 vdd! vdd! pfet l=nA nfin=nB4
MM6 net35 net12 vdd! vdd! pfet l=nA nfin=nB3
MM5 net34 net23 vdd! vdd! pfet l=nA nfin=nB4
MM14 net10 Vbiasn2 net33 gnd! nfet l=nA nfin=nB5
MM13 Voutn Vbiasn2 net31 gnd! nfet l=nA nfin=nB5
MM3 net23 Vinp net17 gnd! nfet l=nA nfin=nB6
MM0 net12 Vinn net17 gnd! nfet l=nA nfin=nB6
MM4 net17 Vbiasn gnd! gnd! nfet l=nA nfin=nB7
MM8 net33 net10 gnd! gnd! nfet l=nA nfin=nB8
MM7 net31 net10 gnd! gnd! nfet l=nA nfin=nB8
ends single_ended_cascode_current_mirror

subckt LG_load_biasn Vbiasn1 Vbiasn2 Biasp
*.PININFO Vbiasn1:O Vbiasn2:O Biasp:I
MM15 Vbiasn2 Vbiasn2 Vbiasn1 gnd! nfet l=nA nfin=nB9
MM13 Vbiasn1 Vbiasn1 gnd! gnd! nfet l=nA nfin=nB10
MM14 Vbiasn2 Biasp vdd! vdd! pfet l=nA nfin=nB11
ends LG_load_biasn

subckt CR6_2 Vbiasn1 Vbiasn2 Vbiasp
*.PININFO Vbiasn1:O Vbiasn2:O Vbiasp:O
MM2 Vbiasp Vbiasn2 Vbiasn1 gnd! nfet l=nA nfin=nB12
MM0 Vbiasn2 Vbiasn1 gnd! gnd! nfet l=nA nfin=nB13
MM4 Vbiasn1 net15 gnd! gnd! nfet l=nA nfin=nB14
MM5 net15 net15 gnd! gnd! nfet l=nA nfin=nB14
MM3 Vbiasp Vbiasp vdd! vdd! pfet l=nA nfin=nB15
MM1 Vbiasn2 Vbiasp vdd! vdd! pfet l=nA nfin=nB15
MM6 net15 Vbiasp vdd! vdd! pfet l=nA nfin=nB16
ends CR6_2

VS (gnd! 0) vsource dc=0 type=dc
V0 (vdd! gnd!) vsource dc=vdd type=dc
V2 (in gnd!) vsource type=dc mag=1
E1 (Vinp cm in gnd!) vcvs gain=.5
E0 (Vinn cm in gnd!) vcvs gain=-0.5
V1 (cm gnd!) vsource dc=vcm type=dc
VN0 (LG_Vbiasn gnd!) vsource dc=lg_vbiasn type=dc
VP0 (LG_Vbiasp2 gnd!) vsource dc=lg_vbiasp2 type=dc
VN1 (LG_Vbiasn1 gnd!) vsource dc=lg_vbiasn1 type=dc
VN2 (Biasn1 gnd!) vsource dc=biasn1 type=dc
VN3 (Biasn2 gnd!) vsource dc=biasn2 type=dc

xiota LG_Vbiasn LG_Vbiasn2 LG_Vbiasp2 Vinn Vinp Voutn single_ended_cascode_current_mirror

xiLG_load_biasn LG_Vbiasn1 LG_Vbiasn2 Biasp LG_load_biasn

xibCR6_2 Biasn1 Biasn2 Biasp CR6_2

simulatorOptions options psfversion="1.4.0" reltol=1e-3 vabstol=1e-6 \
    iabstol=1e-12 temp=tempc tnom=27 scalem=1.0 scale=1.0 gmin=1e-12 rforce=1 \
    maxnotes=5 maxwarns=5 digits=5 cols=80 pivrel=1e-3 \
    sensfile="../psf/sens.output" checklimitdest=psf
    ac ac start=1 stop=100G dec=10 annotate=status
dcOp dc write="spectre.dc" maxiters=150 maxsteps=10000 annotate=status
dcOpInfo info what=oppoint where=rawfile
modelParameter info what=models where=rawfile
element info what=inst where=rawfile
outputParameter info what=output where=rawfile
designParamVals info what=parameters where=rawfile
primitives info what=primitives where=rawfile
subckts info what=subckts where=rawfile
saveOptions options save=allpub
