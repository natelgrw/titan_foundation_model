simulator lang=spectre
global 0
parameters nA={{nA}} nB10={{nB10}} nB11={{nB11}} nB12={{nB12}} nB13={{nB13}} nB14={{nB14}} nB15={{nB15}} nB16={{nB16}} nB17={{nB17}} nB1={{nB1}} nB2={{nB2}} nB3={{nB3}} nB4={{nB4}} nB5={{nB5}} nB6={{nB6}} nB7={{nB7}} nB8={{nB8}} nB9={{nB9}} tempc={{tempc}} vbiasp={{vbiasp}} vcm={{vcm}} vdd={{vdd}}
include "/homes/natelgrw/Documents/TURBO_circuit_optimizer/lstp/7nfet.pm"
include "/homes/natelgrw/Documents/TURBO_circuit_optimizer/lstp/7pfet.pm"

subckt fully_differential Vinn Vinp Voutn Voutp
*.PININFO Vinn:I Vinp:I Voutn:O Voutp:O
MM1 Voutn Vbiasp vdd! vdd! pfet l=nA nfin=nB1
MM2 Voutp Vbiasp vdd! vdd! pfet l=nA nfin=nB1
MM4 net14 Vbiasn gnd! gnd! nfet l=nA nfin=nB2
MM3 Voutn Vinp net14 gnd! nfet l=nA nfin=nB3
MM0 Voutp Vinn net14 gnd! nfet l=nA nfin=nB3
ends fully_differential

subckt fully_differential_gain_boosting Vbiasn Vbiasp Vinn Vinp Voutn Voutp
*.PININFO Vbiasn:I Vbiasp:O Vinn:I Vinp:I Voutn:O Voutp:O
MM8 Voutn net22 net23 gnd! nfet l=nA nfin=nB4
MM7 Voutp net19 net21 gnd! nfet l=nA nfin=nB4
MM3 net23 Vinp net15 gnd! nfet l=nA nfin=nB5
MM0 net21 Vinn net15 gnd! nfet l=nA nfin=nB5
MM4 net15 Vbiasn gnd! gnd! nfet l=nA nfin=nB6
MM6 Voutn net24 net25 vdd pfet l=nA nfin=nB7
MM5 Voutp net20 net12 vdd pfet l=nA nfin=nB7
MM1 net25 Vbiasp vdd! vdd! pfet l=nA nfin=nB8
MM2 net12 Vbiasp vdd! vdd! pfet l=nA nfin=nB8
XI3 net12 net25 net24 net20 fully_differential
XI1 net23 net21 net19 net22 fully_differential
ends fully_differential_gain_boosting

subckt LG_npmos Biasn Vbiasn Vbiasp
*.PININFO Biasn:I Vbiasn:O Vbiasp:O
MM4 Vbiasp Vbiasn gnd! gnd! nfet l=nA nfin=nB9
MM2 Vbiasn Vbiasn gnd! gnd! nfet l=nA nfin=nB10
MM10 neta Biasn gnd! gnd! nfet l=nA nfin=nB11
MM3 Vbiasp Vbiasp vdd! vdd! pfet l=nA nfin=nB12
MM1 Vbiasn neta vdd! vdd! pfet l=nA nfin=nB13
MM0 neta neta vdd! vdd! pfet l=nA nfin=nB13
ends LG_npmos

subckt CR5_2 Vbiasn Vbiasp
*.PININFO Vbiasn:O Vbiasp:O
MM5 net014 net014 gnd! gnd! nfet l=nA nfin=nB14
MM4 net15 net014 gnd! gnd! nfet l=nA nfin=nB14
MM2 Vbiasp Vbiasn net15 gnd! nfet l=nA nfin=nB15
MM0 Vbiasn Vbiasn gnd! gnd! nfet l=nA nfin=nB15
MM6 net014 Vbiasp vdd! vdd! pfet l=nA nfin=nB16
MM3 Vbiasp Vbiasp vdd! vdd! pfet l=nA nfin=nB17
MM1 Vbiasn Vbiasp vdd! vdd! pfet l=nA nfin=nB17
ends CR5_2

VS (gnd! 0) vsource dc=0 type=dc
V0 (vdd! gnd!) vsource dc=vdd type=dc
V2 (in gnd!) vsource type=dc mag=1
E1 (Vinp cm in gnd!) vcvs gain=.5
E0 (Vinn cm in gnd!) vcvs gain=-0.5
V1 (cm gnd!) vsource dc=vcm type=dc
VP0 (Vbiasp gnd!) vsource dc=vbiasp type=dc

xiota LG_Vbiasn LG_Vbiasp Vinn Vinp Voutn Voutp fully_differential_gain_boosting

xiLG_npmos Biasn LG_Vbiasn LG_Vbiasp LG_npmos

xibCR5_2 Biasn Vbiasp CR5_2

simulatorOptions options psfversion="1.4.0" reltol=1e-3 vabstol=1e-6 \
    iabstol=1e-12 temp=tempc tnom=27 scalem=1.0 scale=1.0 gmin=1e-12 rforce=1 \
    maxnotes=5 maxwarns=5 digits=5 cols=80 pivrel=1e-3 \
    sensfile="../psf/sens.output" checklimitdest=psf
    ac ac start=1 stop=100G dec=10 annotate=status
dcOp dc write="spectre.dc" maxiters=150 maxsteps=10000 annotate=status
dcOpInfo info what=oppoint where=rawfile
modelParameter info what=models where=rawfile
element info what=inst where=rawfile
outputParameter info what=output where=rawfile
designParamVals info what=parameters where=rawfile
primitives info what=primitives where=rawfile
subckts info what=subckts where=rawfile
saveOptions options save=allpub
