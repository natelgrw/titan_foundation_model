simulator lang=spectre
global 0
parameters ibias={{ibias}} nA={{nA}} nB0={{nB0}} nB10={{nB10}} nB11={{nB11}} nB12={{nB12}} nB13={{nB13}} nB14={{nB14}} nB15={{nB15}} nB16={{nB16}} nB17={{nB17}} nB18={{nB18}} nB19={{nB19}} nB1={{nB1}} nB20={{nB20}} nB21={{nB21}} nB22={{nB22}} nB23={{nB23}} nB24={{nB24}} nB2={{nB2}} nB3={{nB3}} nB4={{nB4}} nB5={{nB5}} nB6={{nB6}} nB7={{nB7}} nB8={{nB8}} nB9={{nB9}} nC1={{nC1}} nC2={{nC2}} nC3={{nC3}} nC4={{nC4}} tempc={{tempc}} vcm={{vcm}} vdd={{vdd}}
include "/homes/natelgrw/Documents/TURBO_circuit_optimizer/lstp/7nfet.pm"
include "/homes/natelgrw/Documents/TURBO_circuit_optimizer/lstp/7pfet.pm"

subckt  two_stage_fully_differential_op_amp_68_11 ibias in1 in2 out1 out2 gnd! vdd! vref

MM1 ibias ibias outSourceVoltageBiasXXnXX3 outSourceVoltageBiasXXnXX3 nfet l=nA nfin=nB0
MM2 outInputVoltageBiasXXnXX1 outInputVoltageBiasXXnXX1 VoltageBiasXXnXX1Yinner VoltageBiasXXnXX1Yinner nfet l=nA nfin=nB1
MM3 outSourceVoltageBiasXXnXX1 outSourceVoltageBiasXXnXX1 gnd! gnd! nfet l=nA nfin=nB2
MM4 outSourceVoltageBiasXXnXX3 outSourceVoltageBiasXXnXX3 gnd! gnd! nfet l=nA nfin=nB2
MM5 outVoltageBiasXXnXX2 outVoltageBiasXXnXX2 sourceTransconductance sourceTransconductance nfet l=nA nfin=nB3
MM6 inputVoltageBiasXXpXX0 inputVoltageBiasXXpXX0 vdd! vdd! pfet l=nA nfin=nB4
MM7 outFeedback outFeedback vdd! vdd! pfet l=nA nfin=nB4
MM8 outVoltageBiasXXpXX1 outVoltageBiasXXpXX1 vdd! vdd! pfet l=nA nfin=nB5
MM9 FeedbackStageYout1 FeedbackStageYout1 vdd! vdd! pfet l=nA nfin=nB5
MM10 SecondStage1YinnerStageBias outSourceVoltageBiasXXnXX3 gnd! gnd! nfet l=nA nfin=nB6
MM11 SecondStage2YinnerStageBias outSourceVoltageBiasXXnXX3 gnd! gnd! nfet l=nA nfin=nB6
MM12 VoltageBiasXXnXX1Yinner outSourceVoltageBiasXXnXX1 gnd! gnd! nfet l=nA nfin=nB7
MM13 inputVoltageBiasXXpXX0 outSourceVoltageBiasXXnXX3 gnd! gnd! nfet l=nA nfin=nB7
MM14 out1 ibias SecondStage1YinnerStageBias SecondStage1YinnerStageBias nfet l=nA nfin=nB8
MM15 out1FirstStage outVoltageBiasXXnXX2 FirstStageYsourceGCC1 FirstStageYsourceGCC1 nfet l=nA nfin=nB9
MM16 out2 ibias SecondStage2YinnerStageBias SecondStage2YinnerStageBias nfet l=nA nfin=nB10
MM17 out2FirstStage outVoltageBiasXXnXX2 FirstStageYsourceGCC2 FirstStageYsourceGCC2 nfet l=nA nfin=nB11
MM18 outFeedback vref FeedbackStageYsourceTransconductance1 FeedbackStageYsourceTransconductance1 nfet l=nA nfin=nB12
MM19 outFeedback vref FeedbackStageYsourceTransconductance2 FeedbackStageYsourceTransconductance2 nfet l=nA nfin=nB12
MM20 outVoltageBiasXXpXX1 outSourceVoltageBiasXXnXX3 gnd! gnd! nfet l=nA nfin=nB13
MM21 sourceTransconductance outInputVoltageBiasXXnXX1 outSourceVoltageBiasXXnXX1 outSourceVoltageBiasXXnXX1 nfet l=nA nfin=nB14
MM22 FeedbackStageYinnerStageBias1 outSourceVoltageBiasXXnXX3 gnd! gnd! nfet l=nA nfin=nB15
MM23 FeedbackStageYinnerStageBias2 outSourceVoltageBiasXXnXX3 gnd! gnd! nfet l=nA nfin=nB15
MM24 FeedbackStageYout1 out2 FeedbackStageYsourceTransconductance1 FeedbackStageYsourceTransconductance1 nfet l=nA nfin=nB16
MM25 FeedbackStageYout1 out1 FeedbackStageYsourceTransconductance2 FeedbackStageYsourceTransconductance2 nfet l=nA nfin=nB16
MM26 FeedbackStageYsourceTransconductance1 ibias FeedbackStageYinnerStageBias1 FeedbackStageYinnerStageBias1 nfet l=nA nfin=nB17
MM27 FeedbackStageYsourceTransconductance2 ibias FeedbackStageYinnerStageBias2 FeedbackStageYinnerStageBias2 nfet l=nA nfin=nB17
MM28 FirstStageYsourceGCC1 in1 sourceTransconductance sourceTransconductance nfet l=nA nfin=nB18
MM29 FirstStageYsourceGCC2 in2 sourceTransconductance sourceTransconductance nfet l=nA nfin=nB18
MM30 SecondStage1YinnerTransconductance out1FirstStage vdd! vdd! pfet l=nA nfin=nB19
MM31 SecondStage2YinnerTransconductance out2FirstStage vdd! vdd! pfet l=nA nfin=nB19
MM32 out1 outVoltageBiasXXpXX1 SecondStage1YinnerTransconductance SecondStage1YinnerTransconductance pfet l=nA nfin=nB20
MM33 out1FirstStage outFeedback vdd! vdd! pfet l=nA nfin=nB21
MM34 out2 outVoltageBiasXXpXX1 SecondStage2YinnerTransconductance SecondStage2YinnerTransconductance pfet l=nA nfin=nB22
MM35 out2FirstStage outFeedback vdd! vdd! pfet l=nA nfin=nB23
MM36 outInputVoltageBiasXXnXX1 inputVoltageBiasXXpXX0 vdd! vdd! pfet l=nA nfin=nB23
MM37 outVoltageBiasXXnXX2 inputVoltageBiasXXpXX0 vdd! vdd! pfet l=nA nfin=nB24
C1 out1 gnd! capacitor c=nC1
C2 out1FirstStage out1 capacitor c=nC2
C3 out2 gnd! capacitor c=nC3
C4 out2FirstStage out2 capacitor c=nC4
ends two_stage_fully_differential_op_amp_68_11

VS (gnd! 0) vsource dc=0 type=dc
V0 (vdd! gnd!) vsource dc=vdd type=dc
V2 (in gnd!) vsource type=dc mag=1
E1 (Vinp cm in gnd!) vcvs gain=.5
E0 (Vinn cm in gnd!) vcvs gain=-0.5
V1 (cm gnd!) vsource dc=vcm type=dc
I0 (ibias gnd!) isource dc=ibias type=dc

xi0 ibias in1 in2 out gnd! vdd! two_stage_fully_differential_op_amp_68_11

simulatorOptions options psfversion="1.4.0" reltol=1e-3 vabstol=1e-6 \
    iabstol=1e-12 temp=tempc tnom=27 scalem=1.0 scale=1.0 gmin=1e-12 rforce=1 \
    maxnotes=5 maxwarns=5 digits=5 cols=80 pivrel=1e-3 \
    sensfile="../psf/sens.output" checklimitdest=psf
    ac ac start=1 stop=100G dec=10 annotate=status
dcOp dc write="spectre.dc" maxiters=150 maxsteps=10000 annotate=status
dcOpInfo info what=oppoint where=rawfile
modelParameter info what=models where=rawfile
element info what=inst where=rawfile
outputParameter info what=output where=rawfile
designParamVals info what=parameters where=rawfile
primitives info what=primitives where=rawfile
subckts info what=subckts where=rawfile
saveOptions options save=allpub
