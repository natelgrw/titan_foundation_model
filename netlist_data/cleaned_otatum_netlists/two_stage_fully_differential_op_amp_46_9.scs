simulator lang=spectre
global 0
parameters ibias={{ibias}} nA={{nA}} nB0={{nB0}} nB10={{nB10}} nB11={{nB11}} nB12={{nB12}} nB13={{nB13}} nB14={{nB14}} nB15={{nB15}} nB16={{nB16}} nB17={{nB17}} nB18={{nB18}} nB19={{nB19}} nB1={{nB1}} nB20={{nB20}} nB21={{nB21}} nB22={{nB22}} nB23={{nB23}} nB24={{nB24}} nB25={{nB25}} nB26={{nB26}} nB27={{nB27}} nB2={{nB2}} nB3={{nB3}} nB4={{nB4}} nB5={{nB5}} nB6={{nB6}} nB7={{nB7}} nB8={{nB8}} nB9={{nB9}} nC1={{nC1}} nC2={{nC2}} nC3={{nC3}} nC4={{nC4}} tempc={{tempc}} vcm={{vcm}} vdd={{vdd}}
include "/homes/natelgrw/Documents/TURBO_circuit_optimizer/lstp/7nfet.pm"
include "/homes/natelgrw/Documents/TURBO_circuit_optimizer/lstp/7pfet.pm"

subckt  two_stage_fully_differential_op_amp_46_9 ibias in1 in2 out1 out2 gnd! vdd! vref

MM1 outFeedback outFeedback gnd! gnd! nfet l=nA nfin=nB0
MM2 outInputVoltageBiasXXnXX1 outInputVoltageBiasXXnXX1 VoltageBiasXXnXX1Yinner VoltageBiasXXnXX1Yinner nfet l=nA nfin=nB1
MM3 outInputVoltageBiasXXnXX2 outInputVoltageBiasXXnXX2 VoltageBiasXXnXX2Yinner VoltageBiasXXnXX2Yinner nfet l=nA nfin=nB2
MM4 outSourceVoltageBiasXXnXX1 outSourceVoltageBiasXXnXX1 gnd! gnd! nfet l=nA nfin=nB3
MM5 outSourceVoltageBiasXXnXX2 outSourceVoltageBiasXXnXX2 gnd! gnd! nfet l=nA nfin=nB3
MM6 outVoltageBiasXXnXX0 outVoltageBiasXXnXX0 gnd! gnd! nfet l=nA nfin=nB4
MM7 outVoltageBiasXXnXX3 outVoltageBiasXXnXX3 gnd! gnd! nfet l=nA nfin=nB4
MM8 FeedbackStageYout1 FeedbackStageYout1 gnd! gnd! nfet l=nA nfin=nB5
MM9 ibias ibias outSourceVoltageBiasXXpXX2 outSourceVoltageBiasXXpXX2 pfet l=nA nfin=nB6
MM10 outSourceVoltageBiasXXpXX2 outSourceVoltageBiasXXpXX2 vdd! vdd! pfet l=nA nfin=nB7
MM11 outVoltageBiasXXpXX1 outVoltageBiasXXpXX1 sourceTransconductance sourceTransconductance pfet l=nA nfin=nB8
MM12 out1FirstStage outVoltageBiasXXnXX3 FirstStageYinnerTransistorStack1Load2 FirstStageYinnerTransistorStack1Load2 nfet l=nA nfin=nB9
MM13 out1 outInputVoltageBiasXXnXX1 outSourceVoltageBiasXXnXX1 outSourceVoltageBiasXXnXX1 nfet l=nA nfin=nB10
MM14 out2 outInputVoltageBiasXXnXX2 outSourceVoltageBiasXXnXX2 outSourceVoltageBiasXXnXX2 nfet l=nA nfin=nB11
MM15 out2FirstStage outVoltageBiasXXnXX3 FirstStageYinnerTransistorStack2Load2 FirstStageYinnerTransistorStack2Load2 nfet l=nA nfin=nB12
MM16 outVoltageBiasXXpXX1 outVoltageBiasXXnXX0 gnd! gnd! nfet l=nA nfin=nB13
MM17 FirstStageYinnerTransistorStack1Load2 outFeedback gnd! gnd! nfet l=nA nfin=nB13
MM18 FirstStageYinnerTransistorStack2Load2 outFeedback gnd! gnd! nfet l=nA nfin=nB14
MM19 VoltageBiasXXnXX1Yinner outSourceVoltageBiasXXnXX1 gnd! gnd! nfet l=nA nfin=nB14
MM20 VoltageBiasXXnXX2Yinner outSourceVoltageBiasXXnXX2 gnd! gnd! nfet l=nA nfin=nB15
MM21 out1FirstStage outVoltageBiasXXpXX1 FirstStageYsourceGCC1 FirstStageYsourceGCC1 pfet l=nA nfin=nB16
MM22 out1 out1FirstStage vdd! vdd! pfet l=nA nfin=nB17
MM23 out2 out2FirstStage vdd! vdd! pfet l=nA nfin=nB17
MM24 out2FirstStage outVoltageBiasXXpXX1 FirstStageYsourceGCC2 FirstStageYsourceGCC2 pfet l=nA nfin=nB18
MM25 outFeedback vref FeedbackStageYsourceTransconductance1 FeedbackStageYsourceTransconductance1 pfet l=nA nfin=nB19
MM26 outFeedback vref FeedbackStageYsourceTransconductance2 FeedbackStageYsourceTransconductance2 pfet l=nA nfin=nB19
MM27 outInputVoltageBiasXXnXX1 outSourceVoltageBiasXXpXX2 vdd! vdd! pfet l=nA nfin=nB20
MM28 outInputVoltageBiasXXnXX2 outSourceVoltageBiasXXpXX2 vdd! vdd! pfet l=nA nfin=nB20
MM29 outVoltageBiasXXnXX0 outSourceVoltageBiasXXpXX2 vdd! vdd! pfet l=nA nfin=nB21
MM30 outVoltageBiasXXnXX3 outSourceVoltageBiasXXpXX2 vdd! vdd! pfet l=nA nfin=nB21
MM31 sourceTransconductance ibias FirstStageYinnerStageBias FirstStageYinnerStageBias pfet l=nA nfin=nB22
MM32 FeedbackStageYinnerStageBias2 outSourceVoltageBiasXXpXX2 vdd! vdd! pfet l=nA nfin=nB23
MM33 FeedbackStageYinnerStageBias1 outSourceVoltageBiasXXpXX2 vdd! vdd! pfet l=nA nfin=nB23
MM34 FeedbackStageYout1 out2 FeedbackStageYsourceTransconductance1 FeedbackStageYsourceTransconductance1 pfet l=nA nfin=nB24
MM35 FeedbackStageYout1 out1 FeedbackStageYsourceTransconductance2 FeedbackStageYsourceTransconductance2 pfet l=nA nfin=nB24
MM36 FeedbackStageYsourceTransconductance1 ibias FeedbackStageYinnerStageBias1 FeedbackStageYinnerStageBias1 pfet l=nA nfin=nB25
MM37 FeedbackStageYsourceTransconductance2 ibias FeedbackStageYinnerStageBias2 FeedbackStageYinnerStageBias2 pfet l=nA nfin=nB25
MM38 FirstStageYinnerStageBias outSourceVoltageBiasXXpXX2 vdd! vdd! pfet l=nA nfin=nB26
MM39 FirstStageYsourceGCC1 in1 sourceTransconductance sourceTransconductance pfet l=nA nfin=nB27
MM40 FirstStageYsourceGCC2 in2 sourceTransconductance sourceTransconductance pfet l=nA nfin=nB27
C1 out1FirstStage out1 capacitor c=nC1
C2 out1 gnd! capacitor c=nC2
C3 out2 gnd! capacitor c=nC3
C4 out2FirstStage out2 capacitor c=nC4
ends two_stage_fully_differential_op_amp_46_9

VS (gnd! 0) vsource dc=0 type=dc
V0 (vdd! gnd!) vsource dc=vdd type=dc
V2 (in gnd!) vsource type=dc mag=1
E1 (Vinp cm in gnd!) vcvs gain=.5
E0 (Vinn cm in gnd!) vcvs gain=-0.5
V1 (cm gnd!) vsource dc=vcm type=dc
I0 (ibias gnd!) isource dc=ibias type=dc

xi0 ibias in1 in2 out gnd! vdd! two_stage_fully_differential_op_amp_46_9

simulatorOptions options psfversion="1.4.0" reltol=1e-3 vabstol=1e-6 \
    iabstol=1e-12 temp=tempc tnom=27 scalem=1.0 scale=1.0 gmin=1e-12 rforce=1 \
    maxnotes=5 maxwarns=5 digits=5 cols=80 pivrel=1e-3 \
    sensfile="../psf/sens.output" checklimitdest=psf
    ac ac start=1 stop=100G dec=10 annotate=status
dcOp dc write="spectre.dc" maxiters=150 maxsteps=10000 annotate=status
dcOpInfo info what=oppoint where=rawfile
modelParameter info what=models where=rawfile
element info what=inst where=rawfile
outputParameter info what=output where=rawfile
designParamVals info what=parameters where=rawfile
primitives info what=primitives where=rawfile
subckts info what=subckts where=rawfile
saveOptions options save=allpub
