simulator lang=spectre
global 0
parameters ibias={{ibias}} nA={{nA}} nB0={{nB0}} nB10={{nB10}} nB1={{nB1}} nB2={{nB2}} nB3={{nB3}} nB4={{nB4}} nB5={{nB5}} nB6={{nB6}} nB7={{nB7}} nB8={{nB8}} nB9={{nB9}} nC1={{nC1}} tempc={{tempc}} vcm={{vcm}} vdd={{vdd}}
include "/homes/natelgrw/Documents/TURBO_circuit_optimizer/lstp/7nfet.pm"
include "/homes/natelgrw/Documents/TURBO_circuit_optimizer/lstp/7pfet.pm"

subckt  symmetrical_op_amp33 ibias in1 in2 out gnd! vdd!

MM1 inTransconductanceComplementarySecondStage inTransconductanceComplementarySecondStage gnd! gnd! nfet l=nA nfin=nB0
MM2 outFirstStage outFirstStage gnd! gnd! nfet l=nA nfin=nB0
MM3 outVoltageBiasXXnXX0 outVoltageBiasXXnXX0 gnd! gnd! nfet l=nA nfin=nB1
MM4 ibias ibias vdd! vdd! pfet l=nA nfin=nB2
MM5 inOutputStageBiasComplementarySecondStage inOutputStageBiasComplementarySecondStage vdd! vdd! pfet l=nA nfin=nB2
MM6 innerComplementarySecondStage inTransconductanceComplementarySecondStage gnd! gnd! nfet l=nA nfin=nB3
MM7 inOutputStageBiasComplementarySecondStage outVoltageBiasXXnXX0 gnd! gnd! nfet l=nA nfin=nB3
MM8 out outFirstStage gnd! gnd! nfet l=nA nfin=nB4
MM9 inTransconductanceComplementarySecondStage in2 FirstStageYsourceTransconductance FirstStageYsourceTransconductance pfet l=nA nfin=nB5
MM10 innerComplementarySecondStage inOutputStageBiasComplementarySecondStage StageBiasComplementarySecondStageYinner StageBiasComplementarySecondStageYinner pfet l=nA nfin=nB6
MM11 out inOutputStageBiasComplementarySecondStage SecondStageYinnerStageBias SecondStageYinnerStageBias pfet l=nA nfin=nB6
MM12 outFirstStage in1 FirstStageYsourceTransconductance FirstStageYsourceTransconductance pfet l=nA nfin=nB7
MM13 outVoltageBiasXXnXX0 ibias vdd! vdd! pfet l=nA nfin=nB8
MM14 FirstStageYinnerStageBias ibias vdd! vdd! pfet l=nA nfin=nB8
MM15 FirstStageYsourceTransconductance inOutputStageBiasComplementarySecondStage FirstStageYinnerStageBias FirstStageYinnerStageBias pfet l=nA nfin=nB9
MM16 SecondStageYinnerStageBias innerComplementarySecondStage vdd! vdd! pfet l=nA nfin=nB10
MM17 StageBiasComplementarySecondStageYinner innerComplementarySecondStage vdd! vdd! pfet l=nA nfin=nB10
C1 out gnd! capacitor c=nC1
ends symmetrical_op_amp33

VS (gnd! 0) vsource dc=0 type=dc
V0 (vdd! gnd!) vsource dc=vdd type=dc
V2 (in gnd!) vsource type=dc mag=1
E1 (Vinp cm in gnd!) vcvs gain=.5
E0 (Vinn cm in gnd!) vcvs gain=-0.5
V1 (cm gnd!) vsource dc=vcm type=dc
I0 (ibias gnd!) isource dc=ibias type=dc

xi0 ibias in1 in2 out gnd! vdd! symmetrical_op_amp33

simulatorOptions options psfversion="1.4.0" reltol=1e-3 vabstol=1e-6 \
    iabstol=1e-12 temp=tempc tnom=27 scalem=1.0 scale=1.0 gmin=1e-12 rforce=1 \
    maxnotes=5 maxwarns=5 digits=5 cols=80 pivrel=1e-3 \
    sensfile="../psf/sens.output" checklimitdest=psf
    ac ac start=1 stop=100G dec=10 annotate=status
dcOp dc write="spectre.dc" maxiters=150 maxsteps=10000 annotate=status
dcOpInfo info what=oppoint where=rawfile
modelParameter info what=models where=rawfile
element info what=inst where=rawfile
outputParameter info what=output where=rawfile
designParamVals info what=parameters where=rawfile
primitives info what=primitives where=rawfile
subckts info what=subckts where=rawfile
saveOptions options save=allpub
