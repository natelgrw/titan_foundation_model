simulator lang=spectre
global 0
parameters ibias={{ibias}} nA={{nA}} nB0={{nB0}} nB10={{nB10}} nB11={{nB11}} nB12={{nB12}} nB13={{nB13}} nB1={{nB1}} nB2={{nB2}} nB3={{nB3}} nB4={{nB4}} nB5={{nB5}} nB6={{nB6}} nB7={{nB7}} nB8={{nB8}} nB9={{nB9}} nC1={{nC1}} tempc={{tempc}} vcm={{vcm}} vdd={{vdd}}
include "/homes/natelgrw/Documents/TURBO_circuit_optimizer/lstp/7nfet.pm"
include "/homes/natelgrw/Documents/TURBO_circuit_optimizer/lstp/7pfet.pm"

subckt  symmetrical_op_amp144 ibias in1 in2 out gnd! vdd!

MM1 out2FirstStage out2FirstStage gnd! gnd! nfet l=nA nfin=nB0
MM2 outVoltageBiasXXnXX0 outVoltageBiasXXnXX0 gnd! gnd! nfet l=nA nfin=nB0
MM3 ibias ibias vdd! vdd! pfet l=nA nfin=nB1
MM4 inOutputStageBiasComplementarySecondStage inOutputStageBiasComplementarySecondStage vdd! vdd! pfet l=nA nfin=nB1
MM5 inOutputStageBiasComplementarySecondStage outVoltageBiasXXnXX0 gnd! gnd! nfet l=nA nfin=nB2
MM6 inSourceTransconductanceComplementarySecondStage out2FirstStage FirstStageYinnerTransistorStack2Load1 FirstStageYinnerTransistorStack2Load1 nfet l=nA nfin=nB3
MM7 innerComplementarySecondStage out2FirstStage TransconductanceComplementarySecondStageYinner TransconductanceComplementarySecondStageYinner nfet l=nA nfin=nB3
MM8 out out2FirstStage SecondStageYinnerTransconductance SecondStageYinnerTransconductance nfet l=nA nfin=nB4
MM9 out1FirstStage out2FirstStage FirstStageYinnerTransistorStack1Load1 FirstStageYinnerTransistorStack1Load1 nfet l=nA nfin=nB4
MM10 FirstStageYinnerTransistorStack1Load1 out1FirstStage gnd! gnd! nfet l=nA nfin=nB5
MM11 FirstStageYinnerTransistorStack2Load1 inSourceTransconductanceComplementarySecondStage gnd! gnd! nfet l=nA nfin=nB5
MM12 SecondStageYinnerTransconductance out1FirstStage gnd! gnd! nfet l=nA nfin=nB6
MM13 TransconductanceComplementarySecondStageYinner inSourceTransconductanceComplementarySecondStage gnd! gnd! nfet l=nA nfin=nB6
MM14 inSourceTransconductanceComplementarySecondStage in2 FirstStageYsourceTransconductance FirstStageYsourceTransconductance pfet l=nA nfin=nB7
MM15 innerComplementarySecondStage inOutputStageBiasComplementarySecondStage StageBiasComplementarySecondStageYinner StageBiasComplementarySecondStageYinner pfet l=nA nfin=nB8
MM16 out inOutputStageBiasComplementarySecondStage SecondStageYinnerStageBias SecondStageYinnerStageBias pfet l=nA nfin=nB8
MM17 out1FirstStage in1 FirstStageYsourceTransconductance FirstStageYsourceTransconductance pfet l=nA nfin=nB9
MM18 out2FirstStage ibias vdd! vdd! pfet l=nA nfin=nB10
MM19 outVoltageBiasXXnXX0 ibias vdd! vdd! pfet l=nA nfin=nB10
MM20 FirstStageYinnerStageBias ibias vdd! vdd! pfet l=nA nfin=nB11
MM21 FirstStageYsourceTransconductance inOutputStageBiasComplementarySecondStage FirstStageYinnerStageBias FirstStageYinnerStageBias pfet l=nA nfin=nB12
MM22 SecondStageYinnerStageBias innerComplementarySecondStage vdd! vdd! pfet l=nA nfin=nB13
MM23 StageBiasComplementarySecondStageYinner innerComplementarySecondStage vdd! vdd! pfet l=nA nfin=nB13
C1 out gnd! capacitor c=nC1
ends symmetrical_op_amp144

VS (gnd! 0) vsource dc=0 type=dc
V0 (vdd! gnd!) vsource dc=vdd type=dc
V2 (in gnd!) vsource type=dc mag=1
E1 (Vinp cm in gnd!) vcvs gain=.5
E0 (Vinn cm in gnd!) vcvs gain=-0.5
V1 (cm gnd!) vsource dc=vcm type=dc
I0 (ibias gnd!) isource dc=ibias type=dc

xi0 ibias in1 in2 out gnd! vdd! symmetrical_op_amp144

simulatorOptions options psfversion="1.4.0" reltol=1e-3 vabstol=1e-6 \
    iabstol=1e-12 temp=tempc tnom=27 scalem=1.0 scale=1.0 gmin=1e-12 rforce=1 \
    maxnotes=5 maxwarns=5 digits=5 cols=80 pivrel=1e-3 \
    sensfile="../psf/sens.output" checklimitdest=psf
    ac ac start=1 stop=100G dec=10 annotate=status
dcOp dc write="spectre.dc" maxiters=150 maxsteps=10000 annotate=status
dcOpInfo info what=oppoint where=rawfile
modelParameter info what=models where=rawfile
element info what=inst where=rawfile
outputParameter info what=output where=rawfile
designParamVals info what=parameters where=rawfile
primitives info what=primitives where=rawfile
subckts info what=subckts where=rawfile
saveOptions options save=allpub
