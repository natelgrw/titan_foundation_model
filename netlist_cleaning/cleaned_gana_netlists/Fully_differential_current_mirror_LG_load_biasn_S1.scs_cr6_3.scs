simulator lang=spectre
global 0
parameters biasn1={{biasn1}} biasn2={{biasn2}} lg_vbiasn={{lg_vbiasn}} nA={{nA}} nB0={{nB0}} nB10={{nB10}} nB1={{nB1}} nB2={{nB2}} nB3={{nB3}} nB4={{nB4}} nB5={{nB5}} nB6={{nB6}} nB7={{nB7}} nB8={{nB8}} nB9={{nB9}} tempc={{tempc}} vcm={{vcm}} vdd={{vdd}}
include "/homes/natelgrw/Documents/TURBO_circuit_optimizer/lstp/7nfet.pm"
include "/homes/natelgrw/Documents/TURBO_circuit_optimizer/lstp/7pfet.pm"

subckt Fully_differential_current_mirror Vbiasn Vbiasn1 Vinn Vinp Voutn Voutp
MM3 net23 Vinp net19 gnd! nfet l=nA nfin=nB0
MM0 net15 Vinn net19 gnd! nfet l=nA nfin=nB0
MM4 net19 Vbiasn gnd! gnd! nfet l=nA nfin=nB1
MM8 Voutp Vbiasn1 gnd! gnd! nfet l=nA nfin=nB1
MM7 Voutn Vbiasn1 gnd! gnd! nfet l=nA nfin=nB2
MM6 Voutp net15 vdd! vdd! pfet l=nA nfin=nB3
MM5 Voutn net23 vdd! vdd! pfet l=nA nfin=nB3
MM1 net23 net23 vdd! vdd! pfet l=nA nfin=nB4
MM2 net15 net15 vdd! vdd! pfet l=nA nfin=nB4
ends Fully_differential_current_mirror

subckt LG_load_biasn_S1 Vbiasn1 Biasp
MM8 Vbiasn1 Vbiasn1 gnd! gnd! nfet l=nA nfin=nB5
MM10 Vbiasn1 Biasp vdd! vdd! pfet l=nA nfin=nB5
ends LG_load_biasn_S1

subckt CR6_3 Vbiasn1 Vbiasn2 Vbiasp
MM2 Vbiasp Vbiasn2 Vbiasn1 gnd! nfet l=nA nfin=nB6
MM0 Vbiasn2 Vbiasn1 gnd! gnd! nfet l=nA nfin=nB7
MM4 Vbiasn1 net15 gnd! gnd! nfet l=nA nfin=nB7
MM5 net15 net15 gnd! gnd! nfet l=nA nfin=nB8
MM3 Vbiasp Vbiasp vdd! vdd! pfet l=nA nfin=nB9
MM1 Vbiasn2 Vbiasp vdd! vdd! pfet l=nA nfin=nB9
MM6 net15 Vbiasp vdd! vdd! pfet l=nA nfin=nB10
ends CR6_3

VS (gnd! 0) vsource dc=0 type=dc
V0 (vdd! gnd!) vsource dc=vdd type=dc
V2 (in gnd!) vsource type=dc mag=1
E1 (Vinp cm in gnd!) vcvs gain=.5
E0 (Vinn cm in gnd!) vcvs gain=-0.5
V1 (cm gnd!) vsource dc=vcm type=dc
VN0 (LG_Vbiasn gnd!) vsource dc=lg_vbiasn type=dc
VN1 (Biasn1 gnd!) vsource dc=biasn1 type=dc
VN2 (Biasn2 gnd!) vsource dc=biasn2 type=dc

xiota LG_Vbiasn LG_Vbiasn1 Vinn Vinp Voutn Voutp Fully_differential_current_mirror

xiLG_load_biasn_S1 LG_Vbiasn1 Biasp LG_load_biasn_S1

xibCR6_3 Biasn1 Biasn2 Biasp CR6_3

simulatorOptions options psfversion="1.4.0" reltol=1e-3 vabstol=1e-6 \
    iabstol=1e-12 temp=tempc tnom=27 scalem=1.0 scale=1.0 gmin=1e-12 rforce=1 \
    maxnotes=5 maxwarns=5 digits=5 cols=80 pivrel=1e-3 \
    sensfile="../psf/sens.output" checklimitdest=psf
    ac ac start=1 stop=100G dec=10 annotate=status
dcOp dc write="spectre.dc" maxiters=150 maxsteps=10000 annotate=status
dcOpInfo info what=oppoint where=rawfile
modelParameter info what=models where=rawfile
element info what=inst where=rawfile
outputParameter info what=output where=rawfile
designParamVals info what=parameters where=rawfile
primitives info what=primitives where=rawfile
subckts info what=subckts where=rawfile
saveOptions options save=allpub
