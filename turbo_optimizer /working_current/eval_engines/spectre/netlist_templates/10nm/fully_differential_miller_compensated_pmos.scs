simulator lang=spectre
global 0
parameters tempc={{tempc}} nA1={{nA1}} nB1={{nB1}} nA2={{nA2}} nB2={{nB2}} nA3={{nA3}} nB3={{nB3}} nA4={{nA4}} nB4={{nB4}} nA5={{nA5}} nB5={{nB5}} vdd={{vdd}} vcm={{vcm}} vbiasp0={{vbiasp0}} vbiasp1={{vbiasp1}} vbiasn1={{vbiasn1}} cc={{cc}}
include "/homes/dkochar/migration_project/open-source/scs_files/PTM-MG/modelfiles/lstp/10nfet.pm"

include "/homes/dkochar/migration_project/open-source/scs_files/PTM-MG/modelfiles/lstp/10pfet.pm"
//

// single_ended_cascode_current_mirror_pfet Vbiasn1 Vbiasp0 Vbiasp1 Vinn Vinp Voutn Voutp
//.PININFO Vbiasn1:I Vbiasp0:I Vbiasp1:I Vinn:I Vinp:I Voutn:O Voutp:O
MM1 Voutn net21 gnd! gnd! nfet l=nA1 nfin=nB1
MM13 Voutp net25 gnd! gnd! nfet l=nA1 nfin=nB1
MM9 net25 Vbiasn1 gnd! gnd! nfet l=nA2 nfin=nB2
MM8 net21 Vbiasn1 gnd! gnd! nfet l=nA2 nfin=nB2
MM0 Voutn Vbiasp0 vdd! vdd! pfet l=nA3 nfin=nB3
MM12 Voutp Vbiasp0 vdd! vdd! pfet l=nA3 nfin=nB3
MM11 net17 Vbiasp1 vdd! vdd! pfet l=nA5 nfin=nB5
MM10 net25 Vinn net17 net28 pfet l=nA4 nfin=nB4
MM7 net21 Vinp net17 net28 pfet l=nA4 nfin=nB4
CC0 Voutn net21 capacitor c=cc
CC2 Voutp net25 capacitor c=cc

VS (gnd! 0) vsource dc=0 type=dc
V0 (vdd! gnd!) vsource dc=vdd type=dc
V2 (in gnd!) vsource type=dc mag=1
E1 (Vinp cm in gnd!) vcvs gain=.5
E0 (Vinn cm in gnd!) vcvs gain=-0.5
V1 (cm gnd!) vsource dc=vcm type=dc
VP (Vbiasp0 gnd!) vsource dc=vbiasp0 type=dc
VP1 (Vbiasp1 gnd!) vsource dc=vbiasp1 type=dc
VN1 (Vbiasn1 gnd!) vsource dc=vbiasn1 type=dc
simulatorOptions options psfversion="1.4.0" reltol=1e-3 vabstol=1e-6 \
    iabstol=1e-12 temp=tempc tnom=27 scalem=1.0 scale=1.0 gmin=1e-12 rforce=1 \
    maxnotes=5 maxwarns=5 digits=5 cols=80 pivrel=1e-3 \
    sensfile="../psf/sens.output" checklimitdest=psf
ac ac start=1 stop=100G dec=10 annotate=status
dcOp dc write="spectre.dc" maxiters=150 maxsteps=10000 annotate=status
dcOpInfo info what=oppoint where=rawfile
modelParameter info what=models where=rawfile
element info what=inst where=rawfile
outputParameter info what=output where=rawfile
designParamVals info what=parameters where=rawfile
primitives info what=primitives where=rawfile
subckts info what=subckts where=rawfile
save V0:p  MM0:gm MM0:vgs MM0:vds MM0:ids MM0:region  MM1:gm MM1:vgs MM1:vds MM1:ids MM1:region  MM7:gm MM7:vgs MM7:vds MM7:ids MM7:region  MM8:gm MM8:vgs MM8:vds MM8:ids MM8:region  MM9:gm MM9:vgs MM9:vds MM9:ids MM9:region  MM10:gm MM10:vgs MM10:vds MM10:ids MM10:region  MM11:gm MM11:vgs MM11:vds MM11:ids MM11:region  MM12:gm MM12:vgs MM12:vds MM12:ids MM12:region  MM13:gm MM13:vgs MM13:vds MM13:ids MM13:region
saveOptions options save=allpub
