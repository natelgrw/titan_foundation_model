; Open the PSF results directory
resultsDir = "/homes/natelgrw/Documents/titan_foundation_model/results/designs_single_ended_cascode_current_mirror1543/single_ended_cascode_current_mirror1543_0.2_7.0_0.2_19.0_0.27_8.0_0.29_7.0_0.1_5.0_0.21_13.0_0.22_7.0_0.29_17.0_0.52_0.23_0.06/single_ended_cascode_current_mirror1543_0.2_7.0_0.2_19.0_0.27_8.0_0.29_7.0_0.1_5.0_0.21_13.0_0.22_7.0_0.29_17.0_0.52_0.23_0.06.raw/transwp-000_mytran.tran.tran"
openResults(resultsDir)

; Select the specific analysis
selectResult('tran)

; Get the waveform
wave_1 = v("Voutp")

; Export to CSV
ocnPrint(?output "outputvoutp.csv" wave_1 ?precision 15 ?header t)

; Open the PSF results directory
resultsDir = "/homes/natelgrw/Documents/titan_foundation_model/results/designs_single_ended_cascode_current_mirror1543/single_ended_cascode_current_mirror1543_0.2_7.0_0.2_19.0_0.27_8.0_0.29_7.0_0.1_5.0_0.21_13.0_0.22_7.0_0.29_17.0_0.52_0.23_0.06/single_ended_cascode_current_mirror1543_0.2_7.0_0.2_19.0_0.27_8.0_0.29_7.0_0.1_5.0_0.21_13.0_0.22_7.0_0.29_17.0_0.52_0.23_0.06.raw/transwp-000_mytran.tran.tran"
openResults(resultsDir)

; Select the specific analysis
selectResult('tran)

; Get the waveform
wave_2 = v("Vinn")

; Export to CSV
ocnPrint(?output "outputvinn.csv" wave_2 ?precision 15 ?header t)

exit
