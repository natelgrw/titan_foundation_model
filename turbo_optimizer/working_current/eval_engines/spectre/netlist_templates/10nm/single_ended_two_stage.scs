simulator lang=spectre
global 0
parameters tempc={{tempc}} nA1={{nA1}} nB1={{nB1}} nA2={{nA2}} nB2={{nB2}} nA3={{nA3}} nB3={{nB3}} nA4={{nA4}} nB4={{nB4}} nA5={{nA5}} nB5={{nB5}} nA6={{nA6}} nB6={{nB6}} nA7={{nA7}} nB7={{nB7}} vdd={{vdd}} vcm={{vcm}} vbiasn0={{vbiasn0}}
include "/homes/dkochar/migration_project/open-source/scs_files/PTM-MG/modelfiles/lstp/10nfet.pm"

include "/homes/dkochar/migration_project/open-source/scs_files/PTM-MG/modelfiles/lstp/10pfet.pm"
//
//////7

// single_ended_two_stage Vbiasn0 Vinn Vinp Voutp
//.PININFO Vbiasn0:I Vinn:I Vinp:I Voutp:O
MM1 net16 net20 vdd! vdd! pfet l=nA2 nfin=nB2
MM2 net12 net20 vdd! vdd! pfet l=nA2 nfin=nB2
MM9 net9 net12 vdd! vdd! pfet l=nA6 nfin=nB6
MM5 Voutp net16 vdd! vdd! pfet l=nA5 nfin=nB5
MM7 net9 net9 gnd! gnd! nfet l=nA7 nfin=nB7
MM4 net15 Vbiasn0 gnd! gnd! nfet l=nA3 nfin=nB3
MM6 Voutp net9 gnd! gnd! nfet l=nA4 nfin=nB4
MM3 net16 Vinp net15 gnd! nfet l=nA1 nfin=nB1
MM0 net12 Vinn net15 gnd! nfet l=nA1 nfin=nB1

VS (gnd! 0) vsource dc=0 type=dc
V0 (vdd! gnd!) vsource dc=vdd type=dc
V2 (in gnd!) vsource type=dc mag=1
E1 (Vinp cm in gnd!) vcvs gain=.5
E0 (Vinn cm in gnd!) vcvs gain=-0.5
V1 (cm gnd!) vsource dc=vcm type=dc
VN (Vbiasn0 gnd!) vsource dc=vbiasn0 type=dc
simulatorOptions options psfversion="1.4.0" reltol=1e-3 vabstol=1e-6 \
    iabstol=1e-12 temp=tempc tnom=27 scalem=1.0 scale=1.0 gmin=1e-12 rforce=1 \
    maxnotes=5 maxwarns=5 digits=5 cols=80 pivrel=1e-3 \
    sensfile="../psf/sens.output" checklimitdest=psf
ac ac start=1 stop=100G dec=10 annotate=status
dcOp dc write="spectre.dc" maxiters=150 maxsteps=10000 annotate=status
dcOpInfo info what=oppoint where=rawfile
modelParameter info what=models where=rawfile
element info what=inst where=rawfile
outputParameter info what=output where=rawfile
designParamVals info what=parameters where=rawfile
primitives info what=primitives where=rawfile
subckts info what=subckts where=rawfile
save V0:p  MM0:gm MM0:vgs MM0:vds MM0:ids MM0:region  MM1:gm MM1:vgs MM1:vds MM1:ids MM1:region  MM2:gm MM2:vgs MM2:vds MM2:ids MM2:region  MM3:gm MM3:vgs MM3:vds MM3:ids MM3:region  MM4:gm MM4:vgs MM4:vds MM4:ids MM4:region  MM5:gm MM5:vgs MM5:vds MM5:ids MM5:region  MM6:gm MM6:vgs MM6:vds MM6:ids MM6:region  MM7:gm MM7:vgs MM7:vds MM7:ids MM7:region  MM9:gm MM9:vgs MM9:vds MM9:ids MM9:region
saveOptions options save=allpub
