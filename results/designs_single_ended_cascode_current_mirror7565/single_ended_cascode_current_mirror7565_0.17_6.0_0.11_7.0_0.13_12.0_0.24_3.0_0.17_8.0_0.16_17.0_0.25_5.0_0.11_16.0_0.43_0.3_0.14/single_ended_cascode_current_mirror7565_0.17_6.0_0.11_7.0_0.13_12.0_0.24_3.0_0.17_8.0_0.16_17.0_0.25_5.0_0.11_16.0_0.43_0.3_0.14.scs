simulator lang=spectre
global 0 gnd! vdd!
parameters use_tran=0 dc_offset=0 rfeedback_val=10000 gain_n=-0.5 tempc=27.0 nA1=1.661343209653574e-08 nB1=6.0 nA2=1.1010718077775081e-08 nB2=7.0 nA3=1.287933250920954e-08 nB3=12.0 nA4=2.3922057664788927e-08 nB4=3.0 nA5=1.7120977615103015e-08 nB5=8.0 nA6=1.5653585783746926e-08 nB6=17.0 nA7=2.502153078701577e-08 nB7=5.0 nA8=1.1110794726855186e-08 nB8=16.0 vdd=1 vcm=0.5 vbiasp2=0.42558802862684253 vbiasn0=0.300697734668643 vbiasn2=0.13717011032219864
include "/homes/natelgrw/Documents/titan_foundation_model/lstp/7nfet.pm"
include "/homes/natelgrw/Documents/titan_foundation_model/lstp/7pfet.pm"

*.PININFO Vbiasn0:I Vbiasn2:I Vbiasp2:I Vinn:I Vinp:I Voutp:O
MM12 net12 Vbiasp2 net37 vdd! pfet l=nA6 nfin=nB6
MM11 net23 Vbiasp2 net36 vdd! pfet l=nA3 nfin=nB3
MM10 net10 Vbiasp2 net35 vdd! pfet l=nA6 nfin=nB6
MM9 Voutp Vbiasp2 net34 vdd! pfet l=nA3 nfin=nB3
MM2 net37 net12 vdd! vdd! pfet l=nA5 nfin=nB5
MM1 net36 net23 vdd! vdd! pfet l=nA4 nfin=nB4
MM6 net35 net12 vdd! vdd! pfet l=nA5 nfin=nB5
MM5 net34 net23 vdd! vdd! pfet l=nA4 nfin=nB4
MM14 net10 Vbiasn2 net33 gnd! nfet l=nA2 nfin=nB2
MM13 Voutp Vbiasn2 net31 gnd! nfet l=nA2 nfin=nB2
MM3 net23 Vinp net17 gnd! nfet l=nA7 nfin=nB7
MM0 net12 Vinn net17 gnd! nfet l=nA7 nfin=nB7
MM4 net17 Vbiasn0 gnd! gnd! nfet l=nA8 nfin=nB8
MM8 net33 net10 gnd! gnd! nfet l=nA1 nfin=nB1
MM7 net31 net10 gnd! gnd! nfet l=nA1 nfin=nB1

VS (gnd! 0) vsource dc=0 type=dc
V0 (vdd! gnd!) vsource dc=vdd type=dc
V1 (cm gnd!) vsource dc=vcm type=dc

*---Regular Input---
V2 (in gnd!) vsource dc=dc_offset type=dc mag=0.01
E1 (Vinp_norm cm in gnd!) vcvs gain=0.5
E0 (Vinn_norm cm in gnd!) vcvs gain=gain_n

*---Transient Input---
Vstep (in_tran gnd!) vsource type=pulse val0=0.49 val1=0.51 delay=1n rise=10p fall=10p width=20n period=40n
E3 (Vinp_tran cm in_tran gnd!) vcvs gain=0.5
E2 (Vinn_tran cm in_tran gnd!) vcvs gain=-0.5

*--- Switchable Inputs to Core ---
* These drive the real Vinp/Vinn via large res./run_optimizer.shistors (select input path via param)
Rin1 (Vinp Vinp_norm) resistor r=(1 / (1 - use_tran + 1p))
Rin2 (Vinp Vinp_tran) resistor r=(1 / (use_tran + 1p))

Rin3 (Vinn Vinn_norm) resistor r=(1 / (1 - use_tran + 1p))
Rin4 (Vinn Vinn_tran) resistor r=(1 / (use_tran + 1p))

Rfeedback (Vinn Voutp) resistor r=((use_tran * rfeedback_val) + ((1 - use_tran) * 1T))
Ctran (Voutp gnd!) capacitor c=(use_tran * 100f)

VP2 (Vbiasp2 gnd!) vsource dc=vbiasp2 type=dc
VN (Vbiasn0 gnd!) vsource dc=vbiasn0 type=dc
VN2 (Vbiasn2 gnd!) vsource dc=vbiasn2 type=dc

simulatorOptions options rawfmt=psfbin psfversion="1.4.0" reltol=1e-3 vabstol=1e-6 \
    iabstol=1e-12 temp=tempc tnom=27 scalem=1.0 scale=1.0 gmin=1e-12 rforce=1 \
    maxnotes=5 maxwarns=5 digits=5 cols=80 pivrel=1e-3 \
    sensfile="../psf/sens.output" checklimitdest=psf

*NOISE SIMULATION - CALCULATING INTEGRATED NOISE
noise (Voutp 0) noise start=1M stop=500M dec=20 iprobe=V2 annotate=status

*AC SWEEP - CALCULATING GAIN, UGBW, PM, POWER, CMRR
acswp sweep param=gain_n start=-0.5 stop=0.5 step=1 {
    ac ac start=1 stop=100G dec=10 annotate=status
}

*DC SWEEP FROM FROM VOLT=0 TO VOLT=1 IN 0.01 INCREMENTS - CALCULATING LINEARITY & TRANSISTOR STATES
dcswp sweep param=dc_offset start=-0.5 stop=0.5 step=0.001 {
    dcOp dc write="spectre.dc" maxiters=150 maxsteps=10000 annotate=status
}

*TRANSIENT SWEEP
transwp sweep param=use_tran values=[1] {
    mytran tran stop=100n step=100p annotate=status
}

dcOpInfo info what=oppoint where=rawfile
modelParameter info what=models where=rawfile
element info what=inst where=rawfile
outputParameter info what=output where=rawfile
designParamVals info what=parameters where=rawfile
primitives info what=primitives where=rawfile
subckts info what=subckts where=rawfile

save V0:p  MM0:gm MM0:vgs MM0:vds MM0:ids MM0:region  MM1:gm MM1:vgs MM1:vds MM1:ids MM1:region  MM2:gm MM2:vgs MM2:vds MM2:ids MM2:region  MM3:gm MM3:vgs MM3:vds MM3:ids MM3:region  MM4:gm MM4:vgs MM4:vds MM4:ids MM4:region  MM5:gm MM5:vgs MM5:vds MM5:ids MM5:region  MM6:gm MM6:vgs MM6:vds MM6:ids MM6:region  MM7:gm MM7:vgs MM7:vds MM7:ids MM7:region  MM8:gm MM8:vgs MM8:vds MM8:ids MM8:region  MM9:gm MM9:vgs MM9:vds MM9:ids MM9:region  MM10:gm MM10:vgs MM10:vds MM10:ids MM10:region  MM11:gm MM11:vgs MM11:vds MM11:ids MM11:region  MM12:gm MM12:vgs MM12:vds MM12:ids MM12:region  MM13:gm MM13:vgs MM13:vds MM13:ids MM13:region  MM14:gm MM14:vgs MM14:vds MM14:ids MM14:region
saveOptions options save=allpub rawfmt=psfbin
