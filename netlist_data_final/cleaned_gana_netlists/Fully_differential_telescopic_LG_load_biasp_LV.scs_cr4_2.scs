simulator lang=spectre
global 0
parameters lg_vbiasn={{lg_vbiasn}} lg_vbiasp1={{lg_vbiasp1}} nA={{nA}} nB0={{nB0}} nB10={{nB10}} nB11={{nB11}} nB1={{nB1}} nB2={{nB2}} nB3={{nB3}} nB4={{nB4}} nB5={{nB5}} nB6={{nB6}} nB7={{nB7}} nB8={{nB8}} nB9={{nB9}} tempc={{tempc}} vbiasp={{vbiasp}} vcm={{vcm}} vdd={{vdd}}
include "/homes/natelgrw/Documents/TURBO_circuit_optimizer/lstp/7nfet.pm"
include "/homes/natelgrw/Documents/TURBO_circuit_optimizer/lstp/7pfet.pm"

subckt Fully_differential_telescopic Vbiasn Vbiasp1 Vbiasp2 Vinn Vinp Voutn Voutp
MM5 Voutp Vbiasp2 net18 net18 pfet l=nA nfin=nB0
MM6 Voutn Vbiasp2 net13 net13 pfet l=nA nfin=nB0
MM1 net18 Vbiasp1 vdd! vdd! pfet l=nA nfin=nB1
MM2 net13 Vbiasp1 vdd! vdd! pfet l=nA nfin=nB1
MM3 Voutp Vinp net16 gnd! nfet l=nA nfin=nB2
MM0 Voutn Vinn net16 gnd! nfet l=nA nfin=nB2
MM4 net16 Vbiasn gnd! gnd! nfet l=nA nfin=nB3
ends Fully_differential_telescopic

subckt LG_load_biasp_LV Biasn Vbiasp2
MM0 Vbiasp2 Biasn gnd! gnd! nfet l=nA nfin=nB4
MM3 net8 Vbiasp2 vdd! vdd! pfet l=nA nfin=nB5
MM1 Vbiasp2 Vbiasp2 net8 vdd! pfet l=nA nfin=nB5
ends LG_load_biasp_LV

subckt CR4_2 Vbiasn Vbiasp
MM11 net023 net024 Vbiasn gnd! nfet l=nA nfin=nB6
MM8 net025 net010 net023 gnd! nfet l=nA nfin=nB7
MM9 net024 net024 net023 gnd! nfet l=nA nfin=nB7
MM7 net010 net010 net025 gnd! nfet l=nA nfin=nB8
MM2 Vbiasn Vbiasn gnd! gnd! nfet l=nA nfin=nB9
MM0 Vbiasp net025 gnd! gnd! nfet l=nA nfin=nB9
MM10 net024 Vbiasp vdd! vdd! pfet l=nA nfin=nB10
MM4 net010 Vbiasp vdd! vdd! pfet l=nA nfin=nB10
MM3 Vbiasn Vbiasp vdd! vdd! pfet l=nA nfin=nB11
MM1 Vbiasp Vbiasp vdd! vdd! pfet l=nA nfin=nB11
ends CR4_2

VS (gnd! 0) vsource dc=0 type=dc
V0 (vdd! gnd!) vsource dc=vdd type=dc
V2 (in gnd!) vsource type=dc mag=1
E1 (Vinp cm in gnd!) vcvs gain=.5
E0 (Vinn cm in gnd!) vcvs gain=-0.5
V1 (cm gnd!) vsource dc=vcm type=dc
VN0 (LG_Vbiasn gnd!) vsource dc=lg_vbiasn type=dc
VP0 (LG_Vbiasp1 gnd!) vsource dc=lg_vbiasp1 type=dc
VP1 (Vbiasp gnd!) vsource dc=vbiasp type=dc

xiota LG_Vbiasn LG_Vbiasp1 LG_Vbiasp2 Vinn Vinp Voutn Voutp Fully_differential_telescopic

xiLG_load_biasp_LV Biasn LG_Vbiasp2 LG_load_biasp_LV

xibCR4_2 Biasn Vbiasp CR4_2

simulatorOptions options psfversion="1.4.0" reltol=1e-3 vabstol=1e-6 \
    iabstol=1e-12 temp=tempc tnom=27 scalem=1.0 scale=1.0 gmin=1e-12 rforce=1 \
    maxnotes=5 maxwarns=5 digits=5 cols=80 pivrel=1e-3 \
    sensfile="../psf/sens.output" checklimitdest=psf
    ac ac start=1 stop=100G dec=10 annotate=status
dcOp dc write="spectre.dc" maxiters=150 maxsteps=10000 annotate=status
dcOpInfo info what=oppoint where=rawfile
modelParameter info what=models where=rawfile
element info what=inst where=rawfile
outputParameter info what=output where=rawfile
designParamVals info what=parameters where=rawfile
primitives info what=primitives where=rawfile
subckts info what=subckts where=rawfile
saveOptions options save=allpub
