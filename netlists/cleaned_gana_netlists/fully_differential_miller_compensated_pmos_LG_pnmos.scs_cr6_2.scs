simulator lang=spectre
global 0
parameters biasn1={{biasn1}} biasn2={{biasn2}} lg_vbiasn1={{lg_vbiasn1}} lg_vbiasn={{lg_vbiasn}} nA={{nA}} nB10={{nB10}} nB11={{nB11}} nB12={{nB12}} nB13={{nB13}} nB14={{nB14}} nB1={{nB1}} nB2={{nB2}} nB3={{nB3}} nB4={{nB4}} nB5={{nB5}} nB6={{nB6}} nB7={{nB7}} nB8={{nB8}} nB9={{nB9}} nC0={{nC0}} nC1={{nC1}} tempc={{tempc}} vcm={{vcm}} vdd={{vdd}}
include "/homes/natelgrw/Documents/TURBO_circuit_optimizer/lstp/7nfet.pm"
include "/homes/natelgrw/Documents/TURBO_circuit_optimizer/lstp/7pfet.pm"

subckt fully_differential_miller_compensated_pmos Vbiasn1 Vbiasp Vinn Vinp Voutn Voutp
*.PININFO Vbiasn1:I Vbiasp:I Vinn:I Vinp:I Voutn:O Voutp:O
MM1 Voutn net21 gnd! gnd! nfet l=nA nfin=nB1
MM13 Voutp net25 gnd! gnd! nfet l=nA nfin=nB1
MM9 net25 Vbiasn1 gnd! gnd! nfet l=nA nfin=nB2
MM8 net21 Vbiasn1 gnd! gnd! nfet l=nA nfin=nB2
MM0 Voutn Vbiasp vdd! vdd! pfet l=nA nfin=nB3
MM12 Voutp Vbiasp vdd! vdd! pfet l=nA nfin=nB4
MM11 net17 Vbiasp vdd! vdd! pfet l=nA nfin=nB4
MM10 net25 Vinn net17 net28 pfet l=nA nfin=nB5
MM7 net21 Vinp net17 net28 pfet l=nA nfin=nB5
C0 Voutn net21 capacitor c=nC0
C2 Voutp net25 capacitor c=nC2
ends fully_differential_miller_compensated_pmos

subckt LG_pnmos Biasp Vbiasn Vbiasp
*.PININFO Biasp:I Vbiasn:O Vbiasp:O
MM1 Vbiasn Vbiasn gnd! gnd! nfet l=nA nfin=nB6
MM0 Vbiasp net6 gnd! gnd! nfet l=nA nfin=nB7
MM8 net6 net6 gnd! gnd! nfet l=nA nfin=nB7
MM2 Vbiasn Vbiasp vdd! vdd! pfet l=nA nfin=nB8
MM3 Vbiasp Vbiasp vdd! vdd! pfet l=nA nfin=nB8
MM10 net6 Biasp vdd! vdd! pfet l=nA nfin=nB9
ends LG_pnmos

subckt CR6_2 Vbiasn1 Vbiasn2 Vbiasp
*.PININFO Vbiasn1:O Vbiasn2:O Vbiasp:O
MM2 Vbiasp Vbiasn2 Vbiasn1 gnd! nfet l=nA nfin=nB10
MM0 Vbiasn2 Vbiasn1 gnd! gnd! nfet l=nA nfin=nB11
MM4 Vbiasn1 net15 gnd! gnd! nfet l=nA nfin=nB12
MM5 net15 net15 gnd! gnd! nfet l=nA nfin=nB12
MM3 Vbiasp Vbiasp vdd! vdd! pfet l=nA nfin=nB13
MM1 Vbiasn2 Vbiasp vdd! vdd! pfet l=nA nfin=nB13
MM6 net15 Vbiasp vdd! vdd! pfet l=nA nfin=nB14
ends CR6_2

VS (gnd! 0) vsource dc=0 type=dc
V0 (vdd! gnd!) vsource dc=vdd type=dc
V2 (in gnd!) vsource type=dc mag=1
E1 (Vinp cm in gnd!) vcvs gain=.5
E0 (Vinn cm in gnd!) vcvs gain=-0.5
V1 (cm gnd!) vsource dc=vcm type=dc
VN0 (LG_Vbiasn1 gnd!) vsource dc=lg_vbiasn1 type=dc
VN1 (LG_Vbiasn gnd!) vsource dc=lg_vbiasn type=dc
VN2 (Biasn1 gnd!) vsource dc=biasn1 type=dc
VN3 (Biasn2 gnd!) vsource dc=biasn2 type=dc

xiota LG_Vbiasn1 LG_Vbiasp Vinn Vinp Voutn Voutp fully_differential_miller_compensated_pmos

xiLG_pnmos Biasp LG_Vbiasn LG_Vbiasp LG_pnmos

xibCR6_2 Biasn1 Biasn2 Biasp CR6_2

simulatorOptions options psfversion="1.4.0" reltol=1e-3 vabstol=1e-6 \
    iabstol=1e-12 temp=tempc tnom=27 scalem=1.0 scale=1.0 gmin=1e-12 rforce=1 \
    maxnotes=5 maxwarns=5 digits=5 cols=80 pivrel=1e-3 \
    sensfile="../psf/sens.output" checklimitdest=psf
    ac ac start=1 stop=100G dec=10 annotate=status
dcOp dc write="spectre.dc" maxiters=150 maxsteps=10000 annotate=status
dcOpInfo info what=oppoint where=rawfile
modelParameter info what=models where=rawfile
element info what=inst where=rawfile
outputParameter info what=output where=rawfile
designParamVals info what=parameters where=rawfile
primitives info what=primitives where=rawfile
subckts info what=subckts where=rawfile
saveOptions options save=allpub
