simulator lang=spectre
global 0
parameters biasn={{biasn}} lg_vbiasn1={{lg_vbiasn1}} lg_vbiasp1={{lg_vbiasp1}} lg_vbiasp2={{lg_vbiasp2}} lg_vbiasp={{lg_vbiasp}} nA={{nA}} nB10={{nB10}} nB11={{nB11}} nB12={{nB12}} nB13={{nB13}} nB14={{nB14}} nB15={{nB15}} nB16={{nB16}} nB17={{nB17}} nB18={{nB18}} nB19={{nB19}} nB1={{nB1}} nB20={{nB20}} nB2={{nB2}} nB3={{nB3}} nB4={{nB4}} nB5={{nB5}} nB6={{nB6}} nB7={{nB7}} nB8={{nB8}} nB9={{nB9}} tempc={{tempc}} vcm={{vcm}} vdd={{vdd}}
include "/homes/natelgrw/Documents/TURBO_circuit_optimizer/lstp/7nfet.pm"
include "/homes/natelgrw/Documents/TURBO_circuit_optimizer/lstp/7pfet.pm"

subckt fully_differential_cascode_current_mirror_pmos Vbiasn1 Vbiasn2 Vbiasp Vbiasp1 Vbiasp2 Vinn Vinp Voutn Voutp
*.PININFO Vbiasn1:I Vbiasn2:I Vbiasp:I Vbiasp1:I Vbiasp2:I Vinn:I Vinp:I Voutn:O Voutp:O
MM1 Voutp Vbiasn2 net37 gnd! nfet l=nA nfin=nB1
MM0 Voutn Vbiasn2 net29 gnd! nfet l=nA nfin=nB2
MM9 net35 Vbiasn2 net34 gnd! nfet l=nA nfin=nB1
MM8 net31 Vbiasn2 net30 gnd! nfet l=nA nfin=nB2
MM12 net37 Vbiasn1 gnd! gnd! nfet l=nA nfin=nB3
MM11 net29 Vbiasn1 gnd! gnd! nfet l=nA nfin=nB4
MM10 net34 Vbiasn1 gnd! gnd! nfet l=nA nfin=nB3
MM4 net30 Vbiasn1 gnd! gnd! nfet l=nA nfin=nB4
MM14 net36 Vbiasp1 vdd! vdd! pfet l=nA nfin=nB5
MM13 net28 Vbiasp1 vdd! vdd! pfet l=nA nfin=nB5
MM3 Voutp Vbiasp2 net36 vdd! pfet l=nA nfin=nB6
MM2 Voutn Vbiasp2 net28 vdd! pfet l=nA nfin=nB6
MM5 net17 Vbiasp vdd! vdd! pfet l=nA nfin=nB7
MM7 net35 Vinn net17 net32 pfet l=nA nfin=nB8
MM6 net31 Vinp net17 net32 pfet l=nA nfin=nB8
ends fully_differential_cascode_current_mirror_pmos

subckt LG_load_biasn_LV Vbiasn2 Biasp
*.PININFO Vbiasn2:O Biasp:I
MM13 net9 Vbiasn2 gnd! gnd! nfet l=nA nfin=nB9
MM15 Vbiasn2 Vbiasn2 net9 gnd! nfet l=nA nfin=nB10
MM14 Vbiasn2 Biasp vdd! vdd! pfet l=nA nfin=nB11
ends LG_load_biasn_LV

subckt CR4_2 Vbiasn Vbiasp
*.PININFO Vbiasn:O Vbiasp:O
MM11 net023 net024 Vbiasn gnd! nfet l=nA nfin=nB12
MM8 net025 net010 net023 gnd! nfet l=nA nfin=nB13
MM9 net024 net024 net023 gnd! nfet l=nA nfin=nB14
MM7 net010 net010 net025 gnd! nfet l=nA nfin=nB15
MM2 Vbiasn Vbiasn gnd! gnd! nfet l=nA nfin=nB16
MM0 Vbiasp net025 gnd! gnd! nfet l=nA nfin=nB17
MM10 net024 Vbiasp vdd! vdd! pfet l=nA nfin=nB18
MM4 net010 Vbiasp vdd! vdd! pfet l=nA nfin=nB19
MM3 Vbiasn Vbiasp vdd! vdd! pfet l=nA nfin=nB18
MM1 Vbiasp Vbiasp vdd! vdd! pfet l=nA nfin=nB20
ends CR4_2

VS (gnd! 0) vsource dc=0 type=dc
V0 (vdd! gnd!) vsource dc=vdd type=dc
V2 (in gnd!) vsource type=dc mag=1
E1 (Vinp cm in gnd!) vcvs gain=.5
E0 (Vinn cm in gnd!) vcvs gain=-0.5
V1 (cm gnd!) vsource dc=vcm type=dc
VN0 (LG_Vbiasn1 gnd!) vsource dc=lg_vbiasn1 type=dc
VP0 (LG_Vbiasp gnd!) vsource dc=lg_vbiasp type=dc
VP1 (LG_Vbiasp1 gnd!) vsource dc=lg_vbiasp1 type=dc
VP2 (LG_Vbiasp2 gnd!) vsource dc=lg_vbiasp2 type=dc
VN1 (Biasn gnd!) vsource dc=biasn type=dc

xiota LG_Vbiasn1 LG_Vbiasn2 LG_Vbiasp LG_Vbiasp1 LG_Vbiasp2 Vinn Vinp Voutn Voutp fully_differential_cascode_current_mirror_pmos

xiLG_load_biasn_LV LG_Vbiasn2 Biasp LG_load_biasn_LV

xibCR4_2 Biasn Biasp CR4_2

simulatorOptions options psfversion="1.4.0" reltol=1e-3 vabstol=1e-6 \
    iabstol=1e-12 temp=tempc tnom=27 scalem=1.0 scale=1.0 gmin=1e-12 rforce=1 \
    maxnotes=5 maxwarns=5 digits=5 cols=80 pivrel=1e-3 \
    sensfile="../psf/sens.output" checklimitdest=psf
    ac ac start=1 stop=100G dec=10 annotate=status
dcOp dc write="spectre.dc" maxiters=150 maxsteps=10000 annotate=status
dcOpInfo info what=oppoint where=rawfile
modelParameter info what=models where=rawfile
element info what=inst where=rawfile
outputParameter info what=output where=rawfile
designParamVals info what=parameters where=rawfile
primitives info what=primitives where=rawfile
subckts info what=subckts where=rawfile
saveOptions options save=allpub
