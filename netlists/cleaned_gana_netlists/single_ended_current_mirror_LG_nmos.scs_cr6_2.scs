simulator lang=spectre
global 0
parameters biasn1={{biasn1}} biasn2={{biasn2}} nA={{nA}} nB10={{nB10}} nB11={{nB11}} nB12={{nB12}} nB1={{nB1}} nB2={{nB2}} nB3={{nB3}} nB4={{nB4}} nB5={{nB5}} nB6={{nB6}} nB7={{nB7}} nB8={{nB8}} nB9={{nB9}} tempc={{tempc}} vcm={{vcm}} vdd={{vdd}}
include "/homes/natelgrw/Documents/TURBO_circuit_optimizer/lstp/7nfet.pm"
include "/homes/natelgrw/Documents/TURBO_circuit_optimizer/lstp/7pfet.pm"

subckt single_ended_current_mirror Vbiasn Vinn Vinp Voutn
*.PININFO Vbiasn:I Vinn:I Vinp:I Voutn:O
MM8 net9 net9 gnd! gnd! nfet l=nA nfin=nB1
MM7 Voutn net9 gnd! gnd! nfet l=nA nfin=nB1
MM3 net20 Vinp net16 gnd! nfet l=nA nfin=nB2
MM0 net11 Vinn net16 gnd! nfet l=nA nfin=nB2
MM4 net16 Vbiasn gnd! gnd! nfet l=nA nfin=nB3
MM6 net9 net11 vdd! vdd! pfet l=nA nfin=nB4
MM5 Voutn net20 vdd! vdd! pfet l=nA nfin=nB5
MM1 net20 net20 vdd! vdd! pfet l=nA nfin=nB5
MM2 net11 net11 vdd! vdd! pfet l=nA nfin=nB4
ends single_ended_current_mirror

subckt LG_nmos Biasp Vbiasn
*.PININFO Biasp:I Vbiasn:O
MM8 Vbiasn Vbiasn gnd! gnd! nfet l=nA nfin=nB6
MM10 Vbiasn Biasp vdd! vdd! pfet l=nA nfin=nB7
ends LG_nmos

subckt CR6_2 Vbiasn1 Vbiasn2 Vbiasp
*.PININFO Vbiasn1:O Vbiasn2:O Vbiasp:O
MM2 Vbiasp Vbiasn2 Vbiasn1 gnd! nfet l=nA nfin=nB8
MM0 Vbiasn2 Vbiasn1 gnd! gnd! nfet l=nA nfin=nB9
MM4 Vbiasn1 net15 gnd! gnd! nfet l=nA nfin=nB10
MM5 net15 net15 gnd! gnd! nfet l=nA nfin=nB10
MM3 Vbiasp Vbiasp vdd! vdd! pfet l=nA nfin=nB11
MM1 Vbiasn2 Vbiasp vdd! vdd! pfet l=nA nfin=nB11
MM6 net15 Vbiasp vdd! vdd! pfet l=nA nfin=nB12
ends CR6_2

VS (gnd! 0) vsource dc=0 type=dc
V0 (vdd! gnd!) vsource dc=vdd type=dc
V2 (in gnd!) vsource type=dc mag=1
E1 (Vinp cm in gnd!) vcvs gain=.5
E0 (Vinn cm in gnd!) vcvs gain=-0.5
V1 (cm gnd!) vsource dc=vcm type=dc
VN0 (Biasn1 gnd!) vsource dc=biasn1 type=dc
VN1 (Biasn2 gnd!) vsource dc=biasn2 type=dc

xiota LG_Vbiasn Vinn Vinp Voutn single_ended_current_mirror

xiLG_nmos Biasp LG_Vbiasn LG_nmos

xibCR6_2 Biasn1 Biasn2 Biasp CR6_2

simulatorOptions options psfversion="1.4.0" reltol=1e-3 vabstol=1e-6 \
    iabstol=1e-12 temp=tempc tnom=27 scalem=1.0 scale=1.0 gmin=1e-12 rforce=1 \
    maxnotes=5 maxwarns=5 digits=5 cols=80 pivrel=1e-3 \
    sensfile="../psf/sens.output" checklimitdest=psf
    ac ac start=1 stop=100G dec=10 annotate=status
dcOp dc write="spectre.dc" maxiters=150 maxsteps=10000 annotate=status
dcOpInfo info what=oppoint where=rawfile
modelParameter info what=models where=rawfile
element info what=inst where=rawfile
outputParameter info what=output where=rawfile
designParamVals info what=parameters where=rawfile
primitives info what=primitives where=rawfile
subckts info what=subckts where=rawfile
saveOptions options save=allpub
