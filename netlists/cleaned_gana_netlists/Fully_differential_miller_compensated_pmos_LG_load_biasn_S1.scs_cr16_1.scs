simulator lang=spectre
global 0
parameters lg_vbiasp={{lg_vbiasp}} nA={{nA}} nB1={{nB1}} nB2={{nB2}} nB3={{nB3}} nB4={{nB4}} nB5={{nB5}} nB6={{nB6}} nB7={{nB7}} nB8={{nB8}} nC0={{nC0}} nC1={{nC1}} nR0={{nR0}} nR1={{nR1}} tempc={{tempc}} vcm={{vcm}} vdd={{vdd}}
include "/homes/natelgrw/Documents/TURBO_circuit_optimizer/lstp/7nfet.pm"
include "/homes/natelgrw/Documents/TURBO_circuit_optimizer/lstp/7pfet.pm"

subckt fully_differential_miller_compensated_pmos Vbiasn1 Vbiasp Vinn Vinp Voutn Voutp
*.PININFO Vbiasn1:I Vbiasp:I Vinn:I Vinp:I Voutn:O Voutp:O
MM1 Voutn net21 gnd! gnd! nfet l=nA nfin=nB1
MM13 Voutp net25 gnd! gnd! nfet l=nA nfin=nB1
MM9 net25 Vbiasn1 gnd! gnd! nfet l=nA nfin=nB2
MM8 net21 Vbiasn1 gnd! gnd! nfet l=nA nfin=nB2
MM0 Voutn Vbiasp vdd! vdd! pfet l=nA nfin=nB3
MM12 Voutp Vbiasp vdd! vdd! pfet l=nA nfin=nB4
MM11 net17 Vbiasp vdd! vdd! pfet l=nA nfin=nB4
MM10 net25 Vinn net17 net28 pfet l=nA nfin=nB5
MM7 net21 Vinp net17 net28 pfet l=nA nfin=nB5
C0 Voutn net21 capacitor c=nC0
C2 Voutp net25 capacitor c=nC2
ends fully_differential_miller_compensated_pmos

subckt LG_load_biasn_S1 Vbiasn1 Biasp
*.PININFO Vbiasn1:O Biasp:I
MM8 Vbiasn1 Vbiasn1 gnd! gnd! nfet l=nA nfin=nB6
MM10 Vbiasn1 Biasp vdd! vdd! pfet l=nA nfin=nB7
ends LG_load_biasn_S1

subckt CR16_1 Vbiasp
*.PININFO Vbiasp:O
R0 vdd! net6 resistor r=nR0
R1 Vbiasp gnd! resistor r=nR1
MM2 Vbiasp Vbiasp net6 vdd! pfet l=nA nfin=nB8
ends CR16_1

VS (gnd! 0) vsource dc=0 type=dc
V0 (vdd! gnd!) vsource dc=vdd type=dc
V2 (in gnd!) vsource type=dc mag=1
E1 (Vinp cm in gnd!) vcvs gain=.5
E0 (Vinn cm in gnd!) vcvs gain=-0.5
V1 (cm gnd!) vsource dc=vcm type=dc
VP0 (LG_Vbiasp gnd!) vsource dc=lg_vbiasp type=dc

xiota LG_Vbiasn1 LG_Vbiasp Vinn Vinp Voutn Voutp fully_differential_miller_compensated_pmos

xiLG_load_biasn_S1 LG_Vbiasn1 Biasp LG_load_biasn_S1

xibCR16_1 Biasp CR16_1

simulatorOptions options psfversion="1.4.0" reltol=1e-3 vabstol=1e-6 \
    iabstol=1e-12 temp=tempc tnom=27 scalem=1.0 scale=1.0 gmin=1e-12 rforce=1 \
    maxnotes=5 maxwarns=5 digits=5 cols=80 pivrel=1e-3 \
    sensfile="../psf/sens.output" checklimitdest=psf
    ac ac start=1 stop=100G dec=10 annotate=status
dcOp dc write="spectre.dc" maxiters=150 maxsteps=10000 annotate=status
dcOpInfo info what=oppoint where=rawfile
modelParameter info what=models where=rawfile
element info what=inst where=rawfile
outputParameter info what=output where=rawfile
designParamVals info what=parameters where=rawfile
primitives info what=primitives where=rawfile
subckts info what=subckts where=rawfile
saveOptions options save=allpub
