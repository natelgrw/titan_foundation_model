simulator lang=spectre
global 0
parameters biasn={{biasn}} nA={{nA}} nB10={{nB10}} nB1={{nB1}} nB2={{nB2}} nB3={{nB3}} nB4={{nB4}} nB5={{nB5}} nB6={{nB6}} nB7={{nB7}} nB8={{nB8}} nB9={{nB9}} nR0={{nR0}} tempc={{tempc}} vcm={{vcm}} vdd={{vdd}}
include "/homes/natelgrw/Documents/TURBO_circuit_optimizer/lstp/7nfet.pm"
include "/homes/natelgrw/Documents/TURBO_circuit_optimizer/lstp/7pfet.pm"

subckt single_ended_two_stage Vbiasn Vinn Vinp Voutp
*.PININFO Vbiasn:I Vinn:I Vinp:I Voutp:O
MM1 net16 net20 vdd! vdd! pfet l=nA nfin=nB1
MM2 net12 net20 vdd! vdd! pfet l=nA nfin=nB1
MM9 net9 net12 vdd! vdd! pfet l=nA nfin=nB2
MM5 Voutp net16 vdd! vdd! pfet l=nA nfin=nB2
MM7 net9 net9 gnd! gnd! nfet l=nA nfin=nB3
MM3 net16 Vinp net15 gnd! nfet l=nA nfin=nB4
MM0 net12 Vinn net15 gnd! nfet l=nA nfin=nB4
MM4 net15 Vbiasn gnd! gnd! nfet l=nA nfin=nB5
MM6 Voutp net9 gnd! gnd! nfet l=nA nfin=nB3
ends single_ended_two_stage

subckt LG_nmos Biasp Vbiasn
*.PININFO Biasp:I Vbiasn:O
MM8 Vbiasn Vbiasn gnd! gnd! nfet l=nA nfin=nB6
MM10 Vbiasn Biasp vdd! vdd! pfet l=nA nfin=nB7
ends LG_nmos

subckt CR2_2_wilson Vbiasn Vbiasp
*.PININFO Vbiasn:O Vbiasp:O
R0 Vbiasn gnd! resistor r=nR0
MM2 Vbiasp net12 Vbiasn gnd! nfet l=nA nfin=nB8
MM0 net12 Vbiasn gnd! gnd! nfet l=nA nfin=nB9
MM3 Vbiasp Vbiasp vdd! vdd! pfet l=nA nfin=nB10
MM1 net12 Vbiasp vdd! vdd! pfet l=nA nfin=nB10
ends CR2_2_wilson

VS (gnd! 0) vsource dc=0 type=dc
V0 (vdd! gnd!) vsource dc=vdd type=dc
V2 (in gnd!) vsource type=dc mag=1
E1 (Vinp cm in gnd!) vcvs gain=.5
E0 (Vinn cm in gnd!) vcvs gain=-0.5
V1 (cm gnd!) vsource dc=vcm type=dc
VN0 (Biasn gnd!) vsource dc=biasn type=dc

xiota LG_Vbiasn Vinn Vinp Voutp single_ended_two_stage

xiLG_nmos Biasp LG_Vbiasn LG_nmos

xibCR2_2_wilson Biasn Biasp CR2_2_wilson

simulatorOptions options psfversion="1.4.0" reltol=1e-3 vabstol=1e-6 \
    iabstol=1e-12 temp=tempc tnom=27 scalem=1.0 scale=1.0 gmin=1e-12 rforce=1 \
    maxnotes=5 maxwarns=5 digits=5 cols=80 pivrel=1e-3 \
    sensfile="../psf/sens.output" checklimitdest=psf
    ac ac start=1 stop=100G dec=10 annotate=status
dcOp dc write="spectre.dc" maxiters=150 maxsteps=10000 annotate=status
dcOpInfo info what=oppoint where=rawfile
modelParameter info what=models where=rawfile
element info what=inst where=rawfile
outputParameter info what=output where=rawfile
designParamVals info what=parameters where=rawfile
primitives info what=primitives where=rawfile
subckts info what=subckts where=rawfile
saveOptions options save=allpub
