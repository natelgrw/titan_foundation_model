simulator lang=spectre
global 0
parameters biasn={{biasn}} lg_vbiasn={{lg_vbiasn}} nA={{nA}} nB10={{nB10}} nB1={{nB1}} nB2={{nB2}} nB3={{nB3}} nB4={{nB4}} nB5={{nB5}} nB6={{nB6}} nB7={{nB7}} nB8={{nB8}} nB9={{nB9}} nR0={{nR0}} tempc={{tempc}} vcm={{vcm}} vdd={{vdd}}
include "/homes/natelgrw/Documents/TURBO_circuit_optimizer/lstp/7nfet.pm"
include "/homes/natelgrw/Documents/TURBO_circuit_optimizer/lstp/7pfet.pm"

subckt single_ended_low_voltage_cascode_pmos Vbiasp Vinn Vinp Voutp
*.PININFO Vbiasp:I Vinn:I Vinp:I Voutp:O
MM7 Voutp Vinn net11 net18 pfet l=nA nfin=nB1
MM6 net13 Vinp net11 net18 pfet l=nA nfin=nB1
MM5 net11 Vbiasp vdd! vdd! pfet l=nA nfin=nB2
MM1 Voutp net17 net20 gnd! nfet l=nA nfin=nB3
MM0 net13 net17 net19 gnd! nfet l=nA nfin=nB3
MM9 net20 net13 gnd! gnd! nfet l=nA nfin=nB4
MM8 net19 net13 gnd! gnd! nfet l=nA nfin=nB4
ends single_ended_low_voltage_cascode_pmos

subckt LG_pnmos Biasp Vbiasn Vbiasp
*.PININFO Biasp:I Vbiasn:O Vbiasp:O
MM1 Vbiasn Vbiasn gnd! gnd! nfet l=nA nfin=nB5
MM0 Vbiasp net6 gnd! gnd! nfet l=nA nfin=nB6
MM8 net6 net6 gnd! gnd! nfet l=nA nfin=nB6
MM2 Vbiasn Vbiasp vdd! vdd! pfet l=nA nfin=nB7
MM3 Vbiasp Vbiasp vdd! vdd! pfet l=nA nfin=nB7
MM10 net6 Biasp vdd! vdd! pfet l=nA nfin=nB8
ends LG_pnmos

subckt CR3_2 Vbiasn Vbiasp
*.PININFO Vbiasn:O Vbiasp:O
MM3 Vbiasp Vbiasp vdd! vdd! pfet l=nA nfin=nB9
MM1 Vbiasn Vbiasp vdd! vdd! pfet l=nA nfin=nB9
R0 net15 gnd! resistor r=nR0
MM0 Vbiasn Vbiasn gnd! gnd! nfet l=nA nfin=nB10
MM2 Vbiasp Vbiasn net15 gnd! nfet l=nA nfin=nB10
ends CR3_2

VS (gnd! 0) vsource dc=0 type=dc
V0 (vdd! gnd!) vsource dc=vdd type=dc
V2 (in gnd!) vsource type=dc mag=1
E1 (Vinp cm in gnd!) vcvs gain=.5
E0 (Vinn cm in gnd!) vcvs gain=-0.5
V1 (cm gnd!) vsource dc=vcm type=dc
VN0 (LG_Vbiasn gnd!) vsource dc=lg_vbiasn type=dc
VN1 (Biasn gnd!) vsource dc=biasn type=dc

xiota LG_Vbiasp Vinn Vinp Voutp single_ended_low_voltage_cascode_pmos

xiLG_pnmos Biasp LG_Vbiasn LG_Vbiasp LG_pnmos

xibCR3_2 Biasn Biasp CR3_2

simulatorOptions options psfversion="1.4.0" reltol=1e-3 vabstol=1e-6 \
    iabstol=1e-12 temp=tempc tnom=27 scalem=1.0 scale=1.0 gmin=1e-12 rforce=1 \
    maxnotes=5 maxwarns=5 digits=5 cols=80 pivrel=1e-3 \
    sensfile="../psf/sens.output" checklimitdest=psf
    ac ac start=1 stop=100G dec=10 annotate=status
dcOp dc write="spectre.dc" maxiters=150 maxsteps=10000 annotate=status
dcOpInfo info what=oppoint where=rawfile
modelParameter info what=models where=rawfile
element info what=inst where=rawfile
outputParameter info what=output where=rawfile
designParamVals info what=parameters where=rawfile
primitives info what=primitives where=rawfile
subckts info what=subckts where=rawfile
saveOptions options save=allpub
