simulator lang=spectre
global 0
parameters ibias={{ibias}} nA={{nA}} nB0={{nB0}} nB10={{nB10}} nB11={{nB11}} nB12={{nB12}} nB13={{nB13}} nB14={{nB14}} nB15={{nB15}} nB16={{nB16}} nB17={{nB17}} nB18={{nB18}} nB19={{nB19}} nB1={{nB1}} nB20={{nB20}} nB21={{nB21}} nB22={{nB22}} nB23={{nB23}} nB24={{nB24}} nB25={{nB25}} nB2={{nB2}} nB3={{nB3}} nB4={{nB4}} nB5={{nB5}} nB6={{nB6}} nB7={{nB7}} nB8={{nB8}} nB9={{nB9}} nC1={{nC1}} nC2={{nC2}} nC3={{nC3}} nC4={{nC4}} tempc={{tempc}} vcm={{vcm}} vdd={{vdd}}
include "/homes/natelgrw/Documents/TURBO_circuit_optimizer/lstp/7nfet.pm"
include "/homes/natelgrw/Documents/TURBO_circuit_optimizer/lstp/7pfet.pm"

subckt  two_stage_fully_differential_op_amp_67_5 ibias in1 in2 out1 out2 gnd! vdd! vref

MM1 outInputVoltageBiasXXnXX1 outInputVoltageBiasXXnXX1 VoltageBiasXXnXX1Yinner VoltageBiasXXnXX1Yinner nfet l=nA nfin=nB0
MM2 outSourceVoltageBiasXXnXX1 outSourceVoltageBiasXXnXX1 gnd! gnd! nfet l=nA nfin=nB1
MM3 outVoltageBiasXXnXX2 outVoltageBiasXXnXX2 sourceTransconductance sourceTransconductance nfet l=nA nfin=nB2
MM4 outVoltageBiasXXnXX3 outVoltageBiasXXnXX3 gnd! gnd! nfet l=nA nfin=nB3
MM5 ibias ibias VoltageBiasXXpXX2Yinner VoltageBiasXXpXX2Yinner pfet l=nA nfin=nB4
MM6 outFeedback outFeedback vdd! vdd! pfet l=nA nfin=nB5
MM7 outInputVoltageBiasXXpXX1 outInputVoltageBiasXXpXX1 VoltageBiasXXpXX1Yinner VoltageBiasXXpXX1Yinner pfet l=nA nfin=nB6
MM8 outSourceVoltageBiasXXpXX1 outSourceVoltageBiasXXpXX1 vdd! vdd! pfet l=nA nfin=nB7
MM9 outSourceVoltageBiasXXpXX2 outSourceVoltageBiasXXpXX2 vdd! vdd! pfet l=nA nfin=nB7
MM10 FeedbackStageYout1 FeedbackStageYout1 vdd! vdd! pfet l=nA nfin=nB8
MM11 out1 out1FirstStage gnd! gnd! nfet l=nA nfin=nB9
MM12 out1FirstStage outVoltageBiasXXnXX2 FirstStageYsourceGCC1 FirstStageYsourceGCC1 nfet l=nA nfin=nB10
MM13 out2 out2FirstStage gnd! gnd! nfet l=nA nfin=nB11
MM14 out2FirstStage outVoltageBiasXXnXX2 FirstStageYsourceGCC2 FirstStageYsourceGCC2 nfet l=nA nfin=nB12
MM15 outFeedback vref FeedbackStageYsourceTransconductance1 FeedbackStageYsourceTransconductance1 nfet l=nA nfin=nB13
MM16 outFeedback vref FeedbackStageYsourceTransconductance2 FeedbackStageYsourceTransconductance2 nfet l=nA nfin=nB13
MM17 outInputVoltageBiasXXpXX1 outVoltageBiasXXnXX3 gnd! gnd! nfet l=nA nfin=nB14
MM18 sourceTransconductance outInputVoltageBiasXXnXX1 outSourceVoltageBiasXXnXX1 outSourceVoltageBiasXXnXX1 nfet l=nA nfin=nB15
MM19 FeedbackStageYout1 out2 FeedbackStageYsourceTransconductance1 FeedbackStageYsourceTransconductance1 nfet l=nA nfin=nB16
MM20 FeedbackStageYout1 out1 FeedbackStageYsourceTransconductance2 FeedbackStageYsourceTransconductance2 nfet l=nA nfin=nB16
MM21 FeedbackStageYsourceTransconductance1 outVoltageBiasXXnXX3 gnd! gnd! nfet l=nA nfin=nB17
MM22 FeedbackStageYsourceTransconductance2 outVoltageBiasXXnXX3 gnd! gnd! nfet l=nA nfin=nB17
MM23 FirstStageYsourceGCC1 in1 sourceTransconductance sourceTransconductance nfet l=nA nfin=nB18
MM24 FirstStageYsourceGCC2 in2 sourceTransconductance sourceTransconductance nfet l=nA nfin=nB18
MM25 VoltageBiasXXnXX1Yinner outSourceVoltageBiasXXnXX1 gnd! gnd! nfet l=nA nfin=nB19
MM26 out1 outInputVoltageBiasXXpXX1 outSourceVoltageBiasXXpXX1 outSourceVoltageBiasXXpXX1 pfet l=nA nfin=nB20
MM27 out1FirstStage outFeedback vdd! vdd! pfet l=nA nfin=nB21
MM28 out2 ibias outSourceVoltageBiasXXpXX2 outSourceVoltageBiasXXpXX2 pfet l=nA nfin=nB22
MM29 out2FirstStage outFeedback vdd! vdd! pfet l=nA nfin=nB23
MM30 outInputVoltageBiasXXnXX1 outSourceVoltageBiasXXpXX2 vdd! vdd! pfet l=nA nfin=nB23
MM31 outVoltageBiasXXnXX2 outSourceVoltageBiasXXpXX2 vdd! vdd! pfet l=nA nfin=nB24
MM32 outVoltageBiasXXnXX3 outSourceVoltageBiasXXpXX2 vdd! vdd! pfet l=nA nfin=nB24
MM33 VoltageBiasXXpXX2Yinner outSourceVoltageBiasXXpXX2 vdd! vdd! pfet l=nA nfin=nB25
MM34 VoltageBiasXXpXX1Yinner outSourceVoltageBiasXXpXX1 vdd! vdd! pfet l=nA nfin=nB25
C1 out1 gnd! capacitor c=nC1
C2 out1FirstStage out1 capacitor c=nC2
C3 out2 gnd! capacitor c=nC3
C4 out2FirstStage out2 capacitor c=nC4
ends two_stage_fully_differential_op_amp_67_5

VS (gnd! 0) vsource dc=0 type=dc
V0 (vdd! gnd!) vsource dc=vdd type=dc
V2 (in gnd!) vsource type=dc mag=1
E1 (Vinp cm in gnd!) vcvs gain=.5
E0 (Vinn cm in gnd!) vcvs gain=-0.5
V1 (cm gnd!) vsource dc=vcm type=dc
I0 (ibias gnd!) isource dc=ibias type=dc

xi0 ibias in1 in2 out gnd! vdd! two_stage_fully_differential_op_amp_67_5

simulatorOptions options psfversion="1.4.0" reltol=1e-3 vabstol=1e-6 \
    iabstol=1e-12 temp=tempc tnom=27 scalem=1.0 scale=1.0 gmin=1e-12 rforce=1 \
    maxnotes=5 maxwarns=5 digits=5 cols=80 pivrel=1e-3 \
    sensfile="../psf/sens.output" checklimitdest=psf
    ac ac start=1 stop=100G dec=10 annotate=status
dcOp dc write="spectre.dc" maxiters=150 maxsteps=10000 annotate=status
dcOpInfo info what=oppoint where=rawfile
modelParameter info what=models where=rawfile
element info what=inst where=rawfile
outputParameter info what=output where=rawfile
designParamVals info what=parameters where=rawfile
primitives info what=primitives where=rawfile
subckts info what=subckts where=rawfile
saveOptions options save=allpub
