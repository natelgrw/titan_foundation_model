simulator lang=spectre
global 0
parameters ibias={{ibias}} nA={{nA}} nB0={{nB0}} nB10={{nB10}} nB11={{nB11}} nB12={{nB12}} nB13={{nB13}} nB14={{nB14}} nB15={{nB15}} nB16={{nB16}} nB17={{nB17}} nB1={{nB1}} nB2={{nB2}} nB3={{nB3}} nB4={{nB4}} nB5={{nB5}} nB6={{nB6}} nB7={{nB7}} nB8={{nB8}} nB9={{nB9}} nC1={{nC1}} nC2={{nC2}} tempc={{tempc}} vcm={{vcm}} vdd={{vdd}}
include "/homes/natelgrw/Documents/TURBO_circuit_optimizer/lstp/7nfet.pm"
include "/homes/natelgrw/Documents/TURBO_circuit_optimizer/lstp/7pfet.pm"

subckt  two_stage_single_output_op_amp_98_4 ibias in1 in2 out gnd! vdd!

MM1 inputVoltageBiasXXnXX2 inputVoltageBiasXXnXX2 gnd! gnd! nfet l=nA nfin=nB0
MM2 outVoltageBiasXXnXX1 outVoltageBiasXXnXX1 sourceTransconductance sourceTransconductance nfet l=nA nfin=nB1
MM3 outVoltageBiasXXnXX3 outVoltageBiasXXnXX3 gnd! gnd! nfet l=nA nfin=nB2
MM4 ibias ibias outSourceVoltageBiasXXpXX1 outSourceVoltageBiasXXpXX1 pfet l=nA nfin=nB3
MM5 outSourceVoltageBiasXXpXX1 outSourceVoltageBiasXXpXX1 vdd! vdd! pfet l=nA nfin=nB4
MM6 FirstStageYinnerSourceLoad2 FirstStageYinnerSourceLoad2 FirstStageYinnerTransistorStack1Load2 FirstStageYinnerTransistorStack1Load2 pfet l=nA nfin=nB5
MM7 out inputVoltageBiasXXnXX2 SecondStageYinnerTransconductance SecondStageYinnerTransconductance nfet l=nA nfin=nB6
MM8 outFirstStage outVoltageBiasXXnXX1 FirstStageYsourceGCC2 FirstStageYsourceGCC2 nfet l=nA nfin=nB7
MM9 sourceTransconductance outVoltageBiasXXnXX3 gnd! gnd! nfet l=nA nfin=nB8
MM10 FirstStageYinnerSourceLoad2 outVoltageBiasXXnXX1 FirstStageYsourceGCC1 FirstStageYsourceGCC1 nfet l=nA nfin=nB9
MM11 FirstStageYsourceGCC1 in1 sourceTransconductance sourceTransconductance nfet l=nA nfin=nB10
MM12 FirstStageYsourceGCC2 in2 sourceTransconductance sourceTransconductance nfet l=nA nfin=nB10
MM13 SecondStageYinnerTransconductance outFirstStage gnd! gnd! nfet l=nA nfin=nB11
MM14 inputVoltageBiasXXnXX2 outSourceVoltageBiasXXpXX1 vdd! vdd! pfet l=nA nfin=nB12
MM15 out ibias SecondStageYinnerStageBias SecondStageYinnerStageBias pfet l=nA nfin=nB13
MM16 outFirstStage FirstStageYinnerSourceLoad2 FirstStageYinnerTransistorStack2Load2 FirstStageYinnerTransistorStack2Load2 pfet l=nA nfin=nB14
MM17 outVoltageBiasXXnXX1 outSourceVoltageBiasXXpXX1 vdd! vdd! pfet l=nA nfin=nB15
MM18 outVoltageBiasXXnXX3 outSourceVoltageBiasXXpXX1 vdd! vdd! pfet l=nA nfin=nB15
MM19 FirstStageYinnerTransistorStack2Load2 FirstStageYinnerSourceLoad2 vdd! vdd! pfet l=nA nfin=nB16
MM20 FirstStageYinnerTransistorStack1Load2 FirstStageYinnerSourceLoad2 vdd! vdd! pfet l=nA nfin=nB16
MM21 SecondStageYinnerStageBias outSourceVoltageBiasXXpXX1 vdd! vdd! pfet l=nA nfin=nB17
C1 out gnd! capacitor c=nC1
C2 outFirstStage out capacitor c=nC2
ends two_stage_single_output_op_amp_98_4

VS (gnd! 0) vsource dc=0 type=dc
V0 (vdd! gnd!) vsource dc=vdd type=dc
V2 (in gnd!) vsource type=dc mag=1
E1 (Vinp cm in gnd!) vcvs gain=.5
E0 (Vinn cm in gnd!) vcvs gain=-0.5
V1 (cm gnd!) vsource dc=vcm type=dc
I0 (ibias gnd!) isource dc=ibias type=dc

xi0 ibias in1 in2 out gnd! vdd! two_stage_single_output_op_amp_98_4

simulatorOptions options psfversion="1.4.0" reltol=1e-3 vabstol=1e-6 \
    iabstol=1e-12 temp=tempc tnom=27 scalem=1.0 scale=1.0 gmin=1e-12 rforce=1 \
    maxnotes=5 maxwarns=5 digits=5 cols=80 pivrel=1e-3 \
    sensfile="../psf/sens.output" checklimitdest=psf
    ac ac start=1 stop=100G dec=10 annotate=status
dcOp dc write="spectre.dc" maxiters=150 maxsteps=10000 annotate=status
dcOpInfo info what=oppoint where=rawfile
modelParameter info what=models where=rawfile
element info what=inst where=rawfile
outputParameter info what=output where=rawfile
designParamVals info what=parameters where=rawfile
primitives info what=primitives where=rawfile
subckts info what=subckts where=rawfile
saveOptions options save=allpub
