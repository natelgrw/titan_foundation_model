simulator lang=spectre
global 0
parameters ibias={{ibias}} nA={{nA}} nB0={{nB0}} nB10={{nB10}} nB11={{nB11}} nB12={{nB12}} nB13={{nB13}} nB14={{nB14}} nB15={{nB15}} nB16={{nB16}} nB17={{nB17}} nB1={{nB1}} nB2={{nB2}} nB3={{nB3}} nB4={{nB4}} nB5={{nB5}} nB6={{nB6}} nB7={{nB7}} nB8={{nB8}} nB9={{nB9}} nC1={{nC1}} nC2={{nC2}} tempc={{tempc}} vcm={{vcm}} vdd={{vdd}}
include "/homes/natelgrw/Documents/TURBO_circuit_optimizer/lstp/7nfet.pm"
include "/homes/natelgrw/Documents/TURBO_circuit_optimizer/lstp/7pfet.pm"

subckt  one_stage_fully_differential_op_amp48 ibias in1 in2 out1 out2 gnd! vdd! vref

MM1 outFeedback outFeedback gnd! gnd! nfet l=nA nfin=nB0
MM2 outVoltageBiasXXnXX0 outVoltageBiasXXnXX0 gnd! gnd! nfet l=nA nfin=nB0
MM3 outVoltageBiasXXnXX1 outVoltageBiasXXnXX1 gnd! gnd! nfet l=nA nfin=nB1
MM4 FeedbackStageYout1 FeedbackStageYout1 gnd! gnd! nfet l=nA nfin=nB1
MM5 ibias ibias outSourceVoltageBiasXXpXX3 outSourceVoltageBiasXXpXX3 pfet l=nA nfin=nB2
MM6 outInputVoltageBiasXXpXX1 outInputVoltageBiasXXpXX1 VoltageBiasXXpXX1Yinner VoltageBiasXXpXX1Yinner pfet l=nA nfin=nB3
MM7 outSourceVoltageBiasXXpXX1 outSourceVoltageBiasXXpXX1 vdd! vdd! pfet l=nA nfin=nB4
MM8 outSourceVoltageBiasXXpXX3 outSourceVoltageBiasXXpXX3 vdd! vdd! pfet l=nA nfin=nB4
MM9 outVoltageBiasXXpXX2 outVoltageBiasXXpXX2 sourceTransconductance sourceTransconductance pfet l=nA nfin=nB5
MM10 out1 outVoltageBiasXXnXX1 FirstStageYinnerTransistorStack1Load2 FirstStageYinnerTransistorStack1Load2 nfet l=nA nfin=nB6
MM11 out2 outVoltageBiasXXnXX1 FirstStageYinnerTransistorStack2Load2 FirstStageYinnerTransistorStack2Load2 nfet l=nA nfin=nB6
MM12 outInputVoltageBiasXXpXX1 outVoltageBiasXXnXX0 gnd! gnd! nfet l=nA nfin=nB7
MM13 outVoltageBiasXXpXX2 outVoltageBiasXXnXX0 gnd! gnd! nfet l=nA nfin=nB7
MM14 FirstStageYinnerTransistorStack1Load2 outFeedback gnd! gnd! nfet l=nA nfin=nB8
MM15 FirstStageYinnerTransistorStack2Load2 outFeedback gnd! gnd! nfet l=nA nfin=nB8
MM16 out1 outVoltageBiasXXpXX2 FirstStageYsourceGCC1 FirstStageYsourceGCC1 pfet l=nA nfin=nB9
MM17 out2 outVoltageBiasXXpXX2 FirstStageYsourceGCC2 FirstStageYsourceGCC2 pfet l=nA nfin=nB9
MM18 outFeedback vref FeedbackStageYsourceTransconductance1 FeedbackStageYsourceTransconductance1 pfet l=nA nfin=nB10
MM19 outFeedback vref FeedbackStageYsourceTransconductance2 FeedbackStageYsourceTransconductance2 pfet l=nA nfin=nB10
MM20 outVoltageBiasXXnXX0 outSourceVoltageBiasXXpXX3 vdd! vdd! pfet l=nA nfin=nB11
MM21 outVoltageBiasXXnXX1 outSourceVoltageBiasXXpXX3 vdd! vdd! pfet l=nA nfin=nB11
MM22 sourceTransconductance outInputVoltageBiasXXpXX1 outSourceVoltageBiasXXpXX1 outSourceVoltageBiasXXpXX1 pfet l=nA nfin=nB12
MM23 FeedbackStageYinnerStageBias1 outSourceVoltageBiasXXpXX3 vdd! vdd! pfet l=nA nfin=nB13
MM24 FeedbackStageYinnerStageBias2 outSourceVoltageBiasXXpXX3 vdd! vdd! pfet l=nA nfin=nB13
MM25 FeedbackStageYout1 out2 FeedbackStageYsourceTransconductance1 FeedbackStageYsourceTransconductance1 pfet l=nA nfin=nB14
MM26 FeedbackStageYout1 out1 FeedbackStageYsourceTransconductance2 FeedbackStageYsourceTransconductance2 pfet l=nA nfin=nB14
MM27 FeedbackStageYsourceTransconductance1 ibias FeedbackStageYinnerStageBias1 FeedbackStageYinnerStageBias1 pfet l=nA nfin=nB15
MM28 FeedbackStageYsourceTransconductance2 ibias FeedbackStageYinnerStageBias2 FeedbackStageYinnerStageBias2 pfet l=nA nfin=nB15
MM29 FirstStageYsourceGCC1 in1 sourceTransconductance sourceTransconductance pfet l=nA nfin=nB16
MM30 FirstStageYsourceGCC2 in2 sourceTransconductance sourceTransconductance pfet l=nA nfin=nB16
MM31 VoltageBiasXXpXX1Yinner outSourceVoltageBiasXXpXX1 vdd! vdd! pfet l=nA nfin=nB17
C1 out1 gnd! capacitor c=nC1
C2 out2 gnd! capacitor c=nC2
ends one_stage_fully_differential_op_amp48

VS (gnd! 0) vsource dc=0 type=dc
V0 (vdd! gnd!) vsource dc=vdd type=dc
V2 (in gnd!) vsource type=dc mag=1
E1 (Vinp cm in gnd!) vcvs gain=.5
E0 (Vinn cm in gnd!) vcvs gain=-0.5
V1 (cm gnd!) vsource dc=vcm type=dc
I0 (ibias gnd!) isource dc=ibias type=dc

xi0 ibias in1 in2 out gnd! vdd! one_stage_fully_differential_op_amp48

simulatorOptions options psfversion="1.4.0" reltol=1e-3 vabstol=1e-6 \
    iabstol=1e-12 temp=tempc tnom=27 scalem=1.0 scale=1.0 gmin=1e-12 rforce=1 \
    maxnotes=5 maxwarns=5 digits=5 cols=80 pivrel=1e-3 \
    sensfile="../psf/sens.output" checklimitdest=psf
    ac ac start=1 stop=100G dec=10 annotate=status
dcOp dc write="spectre.dc" maxiters=150 maxsteps=10000 annotate=status
dcOpInfo info what=oppoint where=rawfile
modelParameter info what=models where=rawfile
element info what=inst where=rawfile
outputParameter info what=output where=rawfile
designParamVals info what=parameters where=rawfile
primitives info what=primitives where=rawfile
subckts info what=subckts where=rawfile
saveOptions options save=allpub
