simulator lang=spectre
global 0
parameters ibias={{ibias}} nA={{nA}} nB0={{nB0}} nB10={{nB10}} nB11={{nB11}} nB12={{nB12}} nB13={{nB13}} nB14={{nB14}} nB1={{nB1}} nB2={{nB2}} nB3={{nB3}} nB4={{nB4}} nB5={{nB5}} nB6={{nB6}} nB7={{nB7}} nB8={{nB8}} nB9={{nB9}} nC1={{nC1}} tempc={{tempc}} vcm={{vcm}} vdd={{vdd}}
include "/homes/natelgrw/Documents/TURBO_circuit_optimizer/lstp/7nfet.pm"
include "/homes/natelgrw/Documents/TURBO_circuit_optimizer/lstp/7pfet.pm"

subckt  symmetrical_op_amp172 ibias in1 in2 out gnd! vdd!

MM1 inOutputStageBiasComplementarySecondStage inOutputStageBiasComplementarySecondStage gnd! gnd! nfet l=nA nfin=nB0
MM2 ibias ibias gnd! gnd! nfet l=nA nfin=nB0
MM3 inOutputTransconductanceComplementarySecondStage inOutputTransconductanceComplementarySecondStage inSourceTransconductanceComplementarySecondStage inSourceTransconductanceComplementarySecondStage pfet l=nA nfin=nB1
MM4 inSourceTransconductanceComplementarySecondStage inSourceTransconductanceComplementarySecondStage vdd! vdd! pfet l=nA nfin=nB2
MM5 out1FirstStage out1FirstStage vdd! vdd! pfet l=nA nfin=nB2
MM6 out2FirstStage out2FirstStage out1FirstStage out1FirstStage pfet l=nA nfin=nB3
MM7 outVoltageBiasXXpXX0 outVoltageBiasXXpXX0 vdd! vdd! pfet l=nA nfin=nB4
MM8 inOutputTransconductanceComplementarySecondStage in2 FirstStageYsourceTransconductance FirstStageYsourceTransconductance nfet l=nA nfin=nB5
MM9 innerComplementarySecondStage inOutputStageBiasComplementarySecondStage StageBiasComplementarySecondStageYinner StageBiasComplementarySecondStageYinner nfet l=nA nfin=nB6
MM10 out inOutputStageBiasComplementarySecondStage SecondStageYinnerStageBias SecondStageYinnerStageBias nfet l=nA nfin=nB6
MM11 out2FirstStage in1 FirstStageYsourceTransconductance FirstStageYsourceTransconductance nfet l=nA nfin=nB7
MM12 outVoltageBiasXXpXX0 ibias gnd! gnd! nfet l=nA nfin=nB8
MM13 FirstStageYinnerStageBias ibias gnd! gnd! nfet l=nA nfin=nB8
MM14 FirstStageYsourceTransconductance inOutputStageBiasComplementarySecondStage FirstStageYinnerStageBias FirstStageYinnerStageBias nfet l=nA nfin=nB9
MM15 SecondStageYinnerStageBias innerComplementarySecondStage gnd! gnd! nfet l=nA nfin=nB10
MM16 StageBiasComplementarySecondStageYinner innerComplementarySecondStage gnd! gnd! nfet l=nA nfin=nB10
MM17 inOutputStageBiasComplementarySecondStage outVoltageBiasXXpXX0 vdd! vdd! pfet l=nA nfin=nB11
MM18 innerComplementarySecondStage inOutputTransconductanceComplementarySecondStage TransconductanceComplementarySecondStageYinner TransconductanceComplementarySecondStageYinner pfet l=nA nfin=nB12
MM19 out out2FirstStage SecondStageYinnerTransconductance SecondStageYinnerTransconductance pfet l=nA nfin=nB13
MM20 SecondStageYinnerTransconductance out1FirstStage vdd! vdd! pfet l=nA nfin=nB14
MM21 TransconductanceComplementarySecondStageYinner inSourceTransconductanceComplementarySecondStage vdd! vdd! pfet l=nA nfin=nB14
C1 out gnd! capacitor c=nC1
ends symmetrical_op_amp172

VS (gnd! 0) vsource dc=0 type=dc
V0 (vdd! gnd!) vsource dc=vdd type=dc
V2 (in gnd!) vsource type=dc mag=1
E1 (Vinp cm in gnd!) vcvs gain=.5
E0 (Vinn cm in gnd!) vcvs gain=-0.5
V1 (cm gnd!) vsource dc=vcm type=dc
I0 (ibias gnd!) isource dc=ibias type=dc

xi0 ibias in1 in2 out gnd! vdd! symmetrical_op_amp172

simulatorOptions options psfversion="1.4.0" reltol=1e-3 vabstol=1e-6 \
    iabstol=1e-12 temp=tempc tnom=27 scalem=1.0 scale=1.0 gmin=1e-12 rforce=1 \
    maxnotes=5 maxwarns=5 digits=5 cols=80 pivrel=1e-3 \
    sensfile="../psf/sens.output" checklimitdest=psf
    ac ac start=1 stop=100G dec=10 annotate=status
dcOp dc write="spectre.dc" maxiters=150 maxsteps=10000 annotate=status
dcOpInfo info what=oppoint where=rawfile
modelParameter info what=models where=rawfile
element info what=inst where=rawfile
outputParameter info what=output where=rawfile
designParamVals info what=parameters where=rawfile
primitives info what=primitives where=rawfile
subckts info what=subckts where=rawfile
saveOptions options save=allpub
