simulator lang=spectre
global 0
parameters ibias={{ibias}} nA={{nA}} nB0={{nB0}} nB10={{nB10}} nB11={{nB11}} nB12={{nB12}} nB13={{nB13}} nB14={{nB14}} nB15={{nB15}} nB16={{nB16}} nB17={{nB17}} nB18={{nB18}} nB19={{nB19}} nB1={{nB1}} nB20={{nB20}} nB21={{nB21}} nB22={{nB22}} nB23={{nB23}} nB24={{nB24}} nB25={{nB25}} nB26={{nB26}} nB27={{nB27}} nB28={{nB28}} nB29={{nB29}} nB2={{nB2}} nB30={{nB30}} nB3={{nB3}} nB4={{nB4}} nB5={{nB5}} nB6={{nB6}} nB7={{nB7}} nB8={{nB8}} nB9={{nB9}} nC1={{nC1}} nC2={{nC2}} nC3={{nC3}} nC4={{nC4}} tempc={{tempc}} vcm={{vcm}} vdd={{vdd}}
include "/homes/natelgrw/Documents/TURBO_circuit_optimizer/lstp/7nfet.pm"
include "/homes/natelgrw/Documents/TURBO_circuit_optimizer/lstp/7pfet.pm"

subckt  two_stage_fully_differential_op_amp_56_6 outVoltageBiasXXnXX3 in1 in2 out1 out2 gnd! vdd! vref

MM1 inputVoltageBiasXXnXX2 inputVoltageBiasXXnXX2 gnd! gnd! nfet l=nA nfin=nB0
MM2 outInputVoltageBiasXXnXX1 outInputVoltageBiasXXnXX1 VoltageBiasXXnXX1Yinner VoltageBiasXXnXX1Yinner nfet l=nA nfin=nB1
MM3 outSourceVoltageBiasXXnXX1 outSourceVoltageBiasXXnXX1 gnd! gnd! nfet l=nA nfin=nB2
MM4 outVoltageBiasXXnXX3 outVoltageBiasXXnXX3 gnd! gnd! nfet l=nA nfin=nB2
MM5 inputVoltageBiasXXpXX1 inputVoltageBiasXXpXX1 VoltageBiasXXpXX1Yinner VoltageBiasXXpXX1Yinner pfet l=nA nfin=nB3
MM6 outFeedback outFeedback vdd! vdd! pfet l=nA nfin=nB4
MM7 outInputVoltageBiasXXpXX2 outInputVoltageBiasXXpXX2 VoltageBiasXXpXX2Yinner VoltageBiasXXpXX2Yinner pfet l=nA nfin=nB5
MM8 outSourceVoltageBiasXXpXX1 outSourceVoltageBiasXXpXX1 vdd! vdd! pfet l=nA nfin=nB6
MM9 outSourceVoltageBiasXXpXX2 outSourceVoltageBiasXXpXX2 vdd! vdd! pfet l=nA nfin=nB6
MM10 outVoltageBiasXXpXX0 outVoltageBiasXXpXX0 vdd! vdd! pfet l=nA nfin=nB7
MM11 outVoltageBiasXXpXX3 outVoltageBiasXXpXX3 vdd! vdd! pfet l=nA nfin=nB7
MM12 FeedbackStageYout1 FeedbackStageYout1 vdd! vdd! pfet l=nA nfin=nB8
MM13 inputVoltageBiasXXpXX1 outVoltageBiasXXnXX3 gnd! gnd! nfet l=nA nfin=nB9
MM14 out1 inputVoltageBiasXXnXX2 SecondStage1YinnerTransconductance SecondStage1YinnerTransconductance nfet l=nA nfin=nB10
MM15 out1FirstStage in1 FirstStageYsourceTransconductance FirstStageYsourceTransconductance nfet l=nA nfin=nB11
MM16 out2 inputVoltageBiasXXnXX2 SecondStage2YinnerTransconductance SecondStage2YinnerTransconductance nfet l=nA nfin=nB12
MM17 out2FirstStage in2 FirstStageYsourceTransconductance FirstStageYsourceTransconductance nfet l=nA nfin=nB13
MM18 outFeedback vref FeedbackStageYsourceTransconductance1 FeedbackStageYsourceTransconductance1 nfet l=nA nfin=nB14
MM19 outFeedback vref FeedbackStageYsourceTransconductance2 FeedbackStageYsourceTransconductance2 nfet l=nA nfin=nB14
MM20 outInputVoltageBiasXXpXX2 outVoltageBiasXXnXX3 gnd! gnd! nfet l=nA nfin=nB15
MM21 outVoltageBiasXXpXX0 outVoltageBiasXXnXX3 gnd! gnd! nfet l=nA nfin=nB15
MM22 outVoltageBiasXXpXX3 outVoltageBiasXXnXX3 gnd! gnd! nfet l=nA nfin=nB16
MM23 FeedbackStageYinnerStageBias1 outVoltageBiasXXnXX3 gnd! gnd! nfet l=nA nfin=nB16
MM24 FeedbackStageYinnerStageBias2 outVoltageBiasXXnXX3 gnd! gnd! nfet l=nA nfin=nB17
MM25 FeedbackStageYout1 out2 FeedbackStageYsourceTransconductance1 FeedbackStageYsourceTransconductance1 nfet l=nA nfin=nB18
MM26 FeedbackStageYout1 out1 FeedbackStageYsourceTransconductance2 FeedbackStageYsourceTransconductance2 nfet l=nA nfin=nB18
MM27 FeedbackStageYsourceTransconductance1 inputVoltageBiasXXnXX2 FeedbackStageYinnerStageBias1 FeedbackStageYinnerStageBias1 nfet l=nA nfin=nB19
MM28 FeedbackStageYsourceTransconductance2 inputVoltageBiasXXnXX2 FeedbackStageYinnerStageBias2 FeedbackStageYinnerStageBias2 nfet l=nA nfin=nB19
MM29 FirstStageYsourceTransconductance outInputVoltageBiasXXnXX1 outSourceVoltageBiasXXnXX1 outSourceVoltageBiasXXnXX1 nfet l=nA nfin=nB20
MM30 SecondStage1YinnerTransconductance out1FirstStage gnd! gnd! nfet l=nA nfin=nB21
MM31 SecondStage2YinnerTransconductance out2FirstStage gnd! gnd! nfet l=nA nfin=nB21
MM32 VoltageBiasXXnXX1Yinner outSourceVoltageBiasXXnXX1 gnd! gnd! nfet l=nA nfin=nB22
MM33 out1 inputVoltageBiasXXpXX1 outSourceVoltageBiasXXpXX1 outSourceVoltageBiasXXpXX1 pfet l=nA nfin=nB23
MM34 inputVoltageBiasXXnXX2 outVoltageBiasXXpXX0 vdd! vdd! pfet l=nA nfin=nB24
MM35 out1FirstStage outVoltageBiasXXpXX3 FirstStageYinnerTransistorStack1Load1 FirstStageYinnerTransistorStack1Load1 pfet l=nA nfin=nB25
MM36 out2 outInputVoltageBiasXXpXX2 outSourceVoltageBiasXXpXX2 outSourceVoltageBiasXXpXX2 pfet l=nA nfin=nB26
MM37 out2FirstStage outVoltageBiasXXpXX3 FirstStageYinnerTransistorStack2Load1 FirstStageYinnerTransistorStack2Load1 pfet l=nA nfin=nB27
MM38 outInputVoltageBiasXXnXX1 outVoltageBiasXXpXX0 vdd! vdd! pfet l=nA nfin=nB28
MM39 FirstStageYinnerTransistorStack1Load1 outFeedback vdd! vdd! pfet l=nA nfin=nB28
MM40 FirstStageYinnerTransistorStack2Load1 outFeedback vdd! vdd! pfet l=nA nfin=nB29
MM41 VoltageBiasXXpXX1Yinner outSourceVoltageBiasXXpXX1 vdd! vdd! pfet l=nA nfin=nB29
MM42 VoltageBiasXXpXX2Yinner outSourceVoltageBiasXXpXX2 vdd! vdd! pfet l=nA nfin=nB30
C1 out1 gnd! capacitor c=nC1
C2 out1FirstStage out1 capacitor c=nC2
C3 out2 gnd! capacitor c=nC3
C4 out2FirstStage out2 capacitor c=nC4
ends two_stage_fully_differential_op_amp_56_6

VS (gnd! 0) vsource dc=0 type=dc
V0 (vdd! gnd!) vsource dc=vdd type=dc
V2 (in gnd!) vsource type=dc mag=1
E1 (Vinp cm in gnd!) vcvs gain=.5
E0 (Vinn cm in gnd!) vcvs gain=-0.5
V1 (cm gnd!) vsource dc=vcm type=dc
I0 (ibias gnd!) isource dc=ibias type=dc

xi0 ibias in1 in2 out gnd! vdd! two_stage_fully_differential_op_amp_56_6

simulatorOptions options psfversion="1.4.0" reltol=1e-3 vabstol=1e-6 \
    iabstol=1e-12 temp=tempc tnom=27 scalem=1.0 scale=1.0 gmin=1e-12 rforce=1 \
    maxnotes=5 maxwarns=5 digits=5 cols=80 pivrel=1e-3 \
    sensfile="../psf/sens.output" checklimitdest=psf
    ac ac start=1 stop=100G dec=10 annotate=status
dcOp dc write="spectre.dc" maxiters=150 maxsteps=10000 annotate=status
dcOpInfo info what=oppoint where=rawfile
modelParameter info what=models where=rawfile
element info what=inst where=rawfile
outputParameter info what=output where=rawfile
designParamVals info what=parameters where=rawfile
primitives info what=primitives where=rawfile
subckts info what=subckts where=rawfile
saveOptions options save=allpub
