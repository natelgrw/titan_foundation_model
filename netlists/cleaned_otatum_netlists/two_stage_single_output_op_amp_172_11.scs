simulator lang=spectre
global 0
parameters ibias={{ibias}} nA={{nA}} nB0={{nB0}} nB10={{nB10}} nB11={{nB11}} nB12={{nB12}} nB13={{nB13}} nB1={{nB1}} nB2={{nB2}} nB3={{nB3}} nB4={{nB4}} nB5={{nB5}} nB6={{nB6}} nB7={{nB7}} nB8={{nB8}} nB9={{nB9}} nC1={{nC1}} nC2={{nC2}} tempc={{tempc}} vcm={{vcm}} vdd={{vdd}}
include "/homes/natelgrw/Documents/TURBO_circuit_optimizer/lstp/7nfet.pm"
include "/homes/natelgrw/Documents/TURBO_circuit_optimizer/lstp/7pfet.pm"

subckt  two_stage_single_output_op_amp_172_11 ibias in1 in2 out gnd! vdd!

MM1 inputVoltageBiasXXnXX2 inputVoltageBiasXXnXX2 gnd! gnd! nfet l=nA nfin=nB0
MM2 outVoltageBiasXXnXX1 outVoltageBiasXXnXX1 gnd! gnd! nfet l=nA nfin=nB0
MM3 ibias ibias VoltageBiasXXpXX1Yinner VoltageBiasXXpXX1Yinner pfet l=nA nfin=nB1
MM4 outSourceVoltageBiasXXpXX1 outSourceVoltageBiasXXpXX1 vdd! vdd! pfet l=nA nfin=nB2
MM5 outVoltageBiasXXpXX2 outVoltageBiasXXpXX2 vdd! vdd! pfet l=nA nfin=nB2
MM6 out outVoltageBiasXXnXX1 SecondStageYinnerStageBias SecondStageYinnerStageBias nfet l=nA nfin=nB3
MM7 outFirstStage inputVoltageBiasXXnXX2 gnd! gnd! nfet l=nA nfin=nB4
MM8 outVoltageBiasXXpXX2 inputVoltageBiasXXnXX2 gnd! gnd! nfet l=nA nfin=nB4
MM9 FirstStageYinnerSourceLoad1 inputVoltageBiasXXnXX2 gnd! gnd! nfet l=nA nfin=nB5
MM10 SecondStageYinnerStageBias inputVoltageBiasXXnXX2 gnd! gnd! nfet l=nA nfin=nB5
MM11 inputVoltageBiasXXnXX2 outSourceVoltageBiasXXpXX1 vdd! vdd! pfet l=nA nfin=nB6
MM12 out outVoltageBiasXXpXX2 SecondStageYinnerTransconductance SecondStageYinnerTransconductance pfet l=nA nfin=nB7
MM13 outFirstStage outVoltageBiasXXpXX2 FirstStageYinnerTransistorStack2Load1 FirstStageYinnerTransistorStack2Load1 pfet l=nA nfin=nB7
MM14 outFirstStage in2 FirstStageYsourceTransconductance FirstStageYsourceTransconductance pfet l=nA nfin=nB8
MM15 outVoltageBiasXXnXX1 outSourceVoltageBiasXXpXX1 vdd! vdd! pfet l=nA nfin=nB9
MM16 FirstStageYinnerSourceLoad1 outVoltageBiasXXpXX2 FirstStageYinnerTransistorStack1Load1 FirstStageYinnerTransistorStack1Load1 pfet l=nA nfin=nB10
MM17 FirstStageYinnerSourceLoad1 in1 FirstStageYsourceTransconductance FirstStageYsourceTransconductance pfet l=nA nfin=nB10
MM18 FirstStageYinnerTransistorStack1Load1 FirstStageYinnerSourceLoad1 vdd! vdd! pfet l=nA nfin=nB11
MM19 FirstStageYinnerTransistorStack2Load1 FirstStageYinnerSourceLoad1 vdd! vdd! pfet l=nA nfin=nB11
MM20 FirstStageYsourceTransconductance ibias outSourceVoltageBiasXXpXX1 outSourceVoltageBiasXXpXX1 pfet l=nA nfin=nB12
MM21 SecondStageYinnerTransconductance outFirstStage vdd! vdd! pfet l=nA nfin=nB13
MM22 VoltageBiasXXpXX1Yinner outSourceVoltageBiasXXpXX1 vdd! vdd! pfet l=nA nfin=nB13
C1 out gnd! capacitor c=nC1
C2 outFirstStage out capacitor c=nC2
ends two_stage_single_output_op_amp_172_11

VS (gnd! 0) vsource dc=0 type=dc
V0 (vdd! gnd!) vsource dc=vdd type=dc
V2 (in gnd!) vsource type=dc mag=1
E1 (Vinp cm in gnd!) vcvs gain=.5
E0 (Vinn cm in gnd!) vcvs gain=-0.5
V1 (cm gnd!) vsource dc=vcm type=dc
I0 (ibias gnd!) isource dc=ibias type=dc

xi0 ibias in1 in2 out gnd! vdd! two_stage_single_output_op_amp_172_11

simulatorOptions options psfversion="1.4.0" reltol=1e-3 vabstol=1e-6 \
    iabstol=1e-12 temp=tempc tnom=27 scalem=1.0 scale=1.0 gmin=1e-12 rforce=1 \
    maxnotes=5 maxwarns=5 digits=5 cols=80 pivrel=1e-3 \
    sensfile="../psf/sens.output" checklimitdest=psf
    ac ac start=1 stop=100G dec=10 annotate=status
dcOp dc write="spectre.dc" maxiters=150 maxsteps=10000 annotate=status
dcOpInfo info what=oppoint where=rawfile
modelParameter info what=models where=rawfile
element info what=inst where=rawfile
outputParameter info what=output where=rawfile
designParamVals info what=parameters where=rawfile
primitives info what=primitives where=rawfile
subckts info what=subckts where=rawfile
saveOptions options save=allpub
