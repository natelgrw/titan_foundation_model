simulator lang=spectre
global 0
parameters ibias={{ibias}} nA={{nA}} nB0={{nB0}} nB10={{nB10}} nB11={{nB11}} nB12={{nB12}} nB13={{nB13}} nB14={{nB14}} nB15={{nB15}} nB1={{nB1}} nB2={{nB2}} nB3={{nB3}} nB4={{nB4}} nB5={{nB5}} nB6={{nB6}} nB7={{nB7}} nB8={{nB8}} nB9={{nB9}} nC1={{nC1}} nC2={{nC2}} nC3={{nC3}} nC4={{nC4}} tempc={{tempc}} vcm={{vcm}} vdd={{vdd}}
include "/homes/natelgrw/Documents/TURBO_circuit_optimizer/lstp/7nfet.pm"
include "/homes/natelgrw/Documents/TURBO_circuit_optimizer/lstp/7pfet.pm"

subckt  two_stage_fully_differential_op_amp_17_3 ibias in1 in2 out1 out2 gnd! vdd! vref

MM1 ibias ibias gnd! gnd! nfet l=nA nfin=nB0
MM2 inputVoltageBiasXXpXX1 inputVoltageBiasXXpXX1 vdd! vdd! pfet l=nA nfin=nB1
MM3 outFeedback outFeedback vdd! vdd! pfet l=nA nfin=nB1
MM4 outVoltageBiasXXpXX2 outVoltageBiasXXpXX2 vdd! vdd! pfet l=nA nfin=nB2
MM5 FeedbackStageYout1 FeedbackStageYout1 vdd! vdd! pfet l=nA nfin=nB2
MM6 out1 out1FirstStage gnd! gnd! nfet l=nA nfin=nB3
MM7 inputVoltageBiasXXpXX1 ibias gnd! gnd! nfet l=nA nfin=nB3
MM8 out1FirstStage ibias gnd! gnd! nfet l=nA nfin=nB4
MM9 out2 out2FirstStage gnd! gnd! nfet l=nA nfin=nB4
MM10 out2FirstStage ibias gnd! gnd! nfet l=nA nfin=nB5
MM11 outFeedback vref FeedbackStageYsourceTransconductance1 FeedbackStageYsourceTransconductance1 nfet l=nA nfin=nB6
MM12 outFeedback vref FeedbackStageYsourceTransconductance2 FeedbackStageYsourceTransconductance2 nfet l=nA nfin=nB6
MM13 outVoltageBiasXXpXX2 ibias gnd! gnd! nfet l=nA nfin=nB7
MM14 FeedbackStageYout1 out2 FeedbackStageYsourceTransconductance1 FeedbackStageYsourceTransconductance1 nfet l=nA nfin=nB8
MM15 FeedbackStageYout1 out1 FeedbackStageYsourceTransconductance2 FeedbackStageYsourceTransconductance2 nfet l=nA nfin=nB8
MM16 FeedbackStageYsourceTransconductance1 ibias gnd! gnd! nfet l=nA nfin=nB9
MM17 FeedbackStageYsourceTransconductance2 ibias gnd! gnd! nfet l=nA nfin=nB9
MM18 FirstStageYsourceGCC1 in1 FirstStageYsourceTransconductance FirstStageYsourceTransconductance nfet l=nA nfin=nB10
MM19 FirstStageYsourceGCC2 in2 FirstStageYsourceTransconductance FirstStageYsourceTransconductance nfet l=nA nfin=nB10
MM20 FirstStageYsourceTransconductance ibias gnd! gnd! nfet l=nA nfin=nB11
MM21 out1 inputVoltageBiasXXpXX1 SecondStage1YinnerStageBias SecondStage1YinnerStageBias pfet l=nA nfin=nB12
MM22 out1FirstStage inputVoltageBiasXXpXX1 FirstStageYsourceGCC1 FirstStageYsourceGCC1 pfet l=nA nfin=nB12
MM23 out2 inputVoltageBiasXXpXX1 SecondStage2YinnerStageBias SecondStage2YinnerStageBias pfet l=nA nfin=nB13
MM24 out2FirstStage inputVoltageBiasXXpXX1 FirstStageYsourceGCC2 FirstStageYsourceGCC2 pfet l=nA nfin=nB13
MM25 FirstStageYsourceGCC1 outFeedback vdd! vdd! pfet l=nA nfin=nB14
MM26 FirstStageYsourceGCC2 outFeedback vdd! vdd! pfet l=nA nfin=nB14
MM27 SecondStage1YinnerStageBias outVoltageBiasXXpXX2 vdd! vdd! pfet l=nA nfin=nB15
MM28 SecondStage2YinnerStageBias outVoltageBiasXXpXX2 vdd! vdd! pfet l=nA nfin=nB15
C1 out1 gnd! capacitor c=nC1
C2 out1FirstStage out1 capacitor c=nC2
C3 out2 gnd! capacitor c=nC3
C4 out2FirstStage out2 capacitor c=nC4
ends two_stage_fully_differential_op_amp_17_3

VS (gnd! 0) vsource dc=0 type=dc
V0 (vdd! gnd!) vsource dc=vdd type=dc
V2 (in gnd!) vsource type=dc mag=1
E1 (Vinp cm in gnd!) vcvs gain=.5
E0 (Vinn cm in gnd!) vcvs gain=-0.5
V1 (cm gnd!) vsource dc=vcm type=dc
I0 (ibias gnd!) isource dc=ibias type=dc

xi0 ibias in1 in2 out gnd! vdd! two_stage_fully_differential_op_amp_17_3

simulatorOptions options psfversion="1.4.0" reltol=1e-3 vabstol=1e-6 \
    iabstol=1e-12 temp=tempc tnom=27 scalem=1.0 scale=1.0 gmin=1e-12 rforce=1 \
    maxnotes=5 maxwarns=5 digits=5 cols=80 pivrel=1e-3 \
    sensfile="../psf/sens.output" checklimitdest=psf
    ac ac start=1 stop=100G dec=10 annotate=status
dcOp dc write="spectre.dc" maxiters=150 maxsteps=10000 annotate=status
dcOpInfo info what=oppoint where=rawfile
modelParameter info what=models where=rawfile
element info what=inst where=rawfile
outputParameter info what=output where=rawfile
designParamVals info what=parameters where=rawfile
primitives info what=primitives where=rawfile
subckts info what=subckts where=rawfile
saveOptions options save=allpub
